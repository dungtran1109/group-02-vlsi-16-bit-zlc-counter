** sch_path: /home/me/group-02-vlsi-16-bit-zlc-counter/frontend/xschem/lzc8.sch
.subckt lzc8 A7 A6 V A5 A4 P2 A3 A2 P1 A1 A0 P0
*.PININFO V:O P2:O P1:O P0:O VDD:I GND:I A[7:0]:I
x1 A[7] A[6] A[5] A[4] net1 VDD net2 GND net5 lzc4
x2 A[3] A[2] A[1] A[0] net3 VDD net4 GND net6 lzc4
x3 net1 net3 GND GND VDD VDD V sky130_fd_sc_hd__or2_1
x4 net1 GND GND VDD VDD P2 sky130_fd_sc_hd__inv_1
x5 net2 net4 P2 GND GND VDD VDD P1 sky130_fd_sc_hd__mux2_1
x6 net5 net6 P2 GND GND VDD VDD P0 sky130_fd_sc_hd__mux2_1
.ends

* expanding   symbol:  lzc4.sym # of pins=6
** sym_path: /home/me/group-02-vlsi-16-bit-zlc-counter/frontend/xschem/lzc4.sym
** sch_path: /home/me/group-02-vlsi-16-bit-zlc-counter/frontend/xschem/lzc4.sch
.subckt lzc4 A[3] A[2] A[1] A[0] V VDD P1 GND P0
*.PININFO A[3:0]:I V:O P1:O P0:O VDD:I GND:I
x1 A[3] net1 A[2] VDD net3 GND lzc2
x2 A[1] net2 A[0] VDD net4 GND lzc2
x3 net1 net2 GND GND VDD VDD V sky130_fd_sc_hd__or2_1
x4 net1 GND GND VDD VDD P1 sky130_fd_sc_hd__inv_1
x5 net3 net4 P1 GND GND VDD VDD P0 sky130_fd_sc_hd__mux2_1
.ends

* expanding   symbol:  lzc2.sym # of pins=6
** sym_path: /home/me/group-02-vlsi-16-bit-zlc-counter/frontend/xschem/lzc2.sym
** sch_path: /home/me/group-02-vlsi-16-bit-zlc-counter/frontend/xschem/lzc2.sch
.subckt lzc2 HI V LO VDD P GND
*.PININFO HI:I LO:I V:O P:O VDD:I GND:I
x1 HI LO GND GND VDD VDD V sky130_fd_sc_hd__or2_1
x2 HI GND GND VDD VDD P sky130_fd_sc_hd__inv_1
.ends
