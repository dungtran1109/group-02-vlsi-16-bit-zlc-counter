** sch_path: /home/me/Project/sky130_lzc16/xschem/lzc4.sch
.subckt lzc4 A3 A2 A1 A0 V P1 P0
*.PININFO A3:I A2:I A1:I A0:I V:O P1:O P0:O
x1 A3 net1 A2 net3 lzc2
x2 A1 net2 A0 net4 lzc2
x3 net1 net2 VGND VNB VPB VPWR V sky130_fd_sc_hd__or2_1
x4 net1 VGND VNB VPB VPWR P1 sky130_fd_sc_hd__inv_1
x5 net3 net4 P1 VGND VNB VPB VPWR P0 sky130_fd_sc_hd__mux2_1
.ends

* expanding   symbol:  lzc2.sym # of pins=4
** sym_path: /home/me/Project/sky130_lzc16/xschem/lzc2.sym
** sch_path: /home/me/Project/sky130_lzc16/xschem/lzc2.sch
.subckt lzc2 HI V LO P
*.PININFO HI:I LO:I V:O P:O
x1 HI LO VGND VNB VPB VPWR V sky130_fd_sc_hd__or2_1
x2 HI GND GND VDD VDD P sky130_fd_sc_hd__inv_1
.ends
