** sch_path: /home/me/group-02-vlsi-16-bit-zlc-counter/frontend/xschem/lzc4.sch
.subckt lzc4 A3 A2 V VDD P1 GND A1 A0 P0
*.PININFO A[3:0]:I V:O P1:O P0:O VDD:I GND:I
x1 A[3] net1 A[2] VDD net3 GND lzc2
x2 A[1] net2 A[0] VDD net4 GND lzc2
x3 net1 net2 GND GND VDD VDD V sky130_fd_sc_hd__or2_1
x4 net1 GND GND VDD VDD P1 sky130_fd_sc_hd__inv_1
x5 net3 net4 P1 GND GND VDD VDD P0 sky130_fd_sc_hd__mux2_1
.ends

* expanding   symbol:  lzc2.sym # of pins=6
** sym_path: /home/me/group-02-vlsi-16-bit-zlc-counter/frontend/xschem/lzc2.sym
** sch_path: /home/me/group-02-vlsi-16-bit-zlc-counter/frontend/xschem/lzc2.sch
.subckt lzc2 HI V LO VDD P GND
*.PININFO HI:I LO:I V:O P:O VDD:I GND:I
x1 HI LO GND GND VDD VDD V sky130_fd_sc_hd__or2_1
x2 HI GND GND VDD VDD P sky130_fd_sc_hd__inv_1
.ends
