* NGSPICE file created from lzc16.ext - technology: sky130A

.subckt sky130_fd_sc_hd__or2_1 A B VGND VNB VPB VPWR X
X0 VGND A a_68_297# VNB sky130_fd_pr__nfet_01v8 ad=0.10025 pd=0.985 as=0.0567 ps=0.69 w=0.42 l=0.15
X1 a_68_297# B VGND VNB sky130_fd_pr__nfet_01v8 ad=0.0567 pd=0.69 as=0.1092 ps=1.36 w=0.42 l=0.15
X2 X a_68_297# VGND VNB sky130_fd_pr__nfet_01v8 ad=0.169 pd=1.82 as=0.10025 ps=0.985 w=0.65 l=0.15
X3 VPWR A a_150_297# VPB sky130_fd_pr__pfet_01v8_hvt ad=0.14575 pd=1.335 as=0.0441 ps=0.63 w=0.42 l=0.15
X4 X a_68_297# VPWR VPB sky130_fd_pr__pfet_01v8_hvt ad=0.34 pd=2.68 as=0.14575 ps=1.335 w=1 l=0.15
X5 a_150_297# B a_68_297# VPB sky130_fd_pr__pfet_01v8_hvt ad=0.0441 pd=0.63 as=0.1092 ps=1.36 w=0.42 l=0.15
.ends

.subckt sky130_fd_sc_hd__inv_1 A VGND VNB VPB VPWR Y
X0 Y A VGND VNB sky130_fd_pr__nfet_01v8 ad=0.169 pd=1.82 as=0.169 ps=1.82 w=0.65 l=0.15
X1 Y A VPWR VPB sky130_fd_pr__pfet_01v8_hvt ad=0.26 pd=2.52 as=0.26 ps=2.52 w=1 l=0.15
.ends

.subckt lzc2 VDD LO HI P V GND
Xx1 HI LO GND GND VDD VDD V sky130_fd_sc_hd__or2_1
Xx2 HI GND GND VDD VDD P sky130_fd_sc_hd__inv_1
.ends

.subckt sky130_fd_sc_hd__mux2_1 A0 A1 S VGND VNB VPB VPWR X
X0 VPWR a_505_21# a_535_374# VPB sky130_fd_pr__pfet_01v8_hvt ad=0.0693 pd=0.75 as=0.0441 ps=0.63 w=0.42 l=0.15
X1 a_505_21# S VPWR VPB sky130_fd_pr__pfet_01v8_hvt ad=0.1176 pd=1.4 as=0.0693 ps=0.75 w=0.42 l=0.15
X2 a_218_374# S VPWR VPB sky130_fd_pr__pfet_01v8_hvt ad=0.07665 pd=0.785 as=0.15835 ps=1.395 w=0.42 l=0.15
X3 VGND a_505_21# a_439_47# VNB sky130_fd_pr__nfet_01v8 ad=0.1449 pd=1.11 as=0.0693 ps=0.75 w=0.42 l=0.15
X4 a_76_199# A0 a_218_374# VPB sky130_fd_pr__pfet_01v8_hvt ad=0.1932 pd=1.34 as=0.07665 ps=0.785 w=0.42 l=0.15
X5 a_505_21# S VGND VNB sky130_fd_pr__nfet_01v8 ad=0.1092 pd=1.36 as=0.1449 ps=1.11 w=0.42 l=0.15
X6 a_439_47# A0 a_76_199# VNB sky130_fd_pr__nfet_01v8 ad=0.0693 pd=0.75 as=0.09975 ps=0.895 w=0.42 l=0.15
X7 a_535_374# A1 a_76_199# VPB sky130_fd_pr__pfet_01v8_hvt ad=0.0441 pd=0.63 as=0.1932 ps=1.34 w=0.42 l=0.15
X8 a_76_199# A1 a_218_47# VNB sky130_fd_pr__nfet_01v8 ad=0.09975 pd=0.895 as=0.0693 ps=0.75 w=0.42 l=0.15
X9 a_218_47# S VGND VNB sky130_fd_pr__nfet_01v8 ad=0.0693 pd=0.75 as=0.11285 ps=1.045 w=0.42 l=0.15
X10 VPWR a_76_199# X VPB sky130_fd_pr__pfet_01v8_hvt ad=0.15835 pd=1.395 as=0.26 ps=2.52 w=1 l=0.15
X11 VGND a_76_199# X VNB sky130_fd_pr__nfet_01v8 ad=0.11285 pd=1.045 as=0.169 ps=1.82 w=0.65 l=0.15
.ends

.subckt lzc4 P1 P0 V A[0] A[1] A[2] A[3] VDD GND
Xx1 VDD A[2] A[3] x1/P x4/A GND lzc2
Xx2 VDD A[0] A[1] x2/P x3/B GND lzc2
Xx3 x4/A x3/B GND GND VDD VDD V sky130_fd_sc_hd__or2_1
Xx4 x4/A GND GND VDD VDD P1 sky130_fd_sc_hd__inv_1
Xx5 x1/P x2/P P1 GND GND VDD VDD P0 sky130_fd_sc_hd__mux2_1
.ends

.subckt lzc8 P2 V P0 P1 A[7] A[6] A[5] A[4] A[3] A[2] A[1] A[0] GND VDD
Xx1 x5/A1 x6/A1 x3/B A[0] A[1] A[2] A[3] VDD GND lzc4
Xx2 x5/A0 x6/A0 x4/A A[4] A[5] A[6] A[7] VDD GND lzc4
Xx3 x4/A x3/B GND GND VDD VDD V sky130_fd_sc_hd__or2_1
Xx4 x4/A GND GND VDD VDD P2 sky130_fd_sc_hd__inv_1
Xx5 x5/A0 x5/A1 P2 GND GND VDD VDD P1 sky130_fd_sc_hd__mux2_1
Xx6 x6/A0 x6/A1 P2 GND GND VDD VDD P0 sky130_fd_sc_hd__mux2_1
.ends

.subckt sky130_fd_sc_hd__and2_1 A B VGND VNB VPB VPWR X
X0 VPWR B a_59_75# VPB sky130_fd_pr__pfet_01v8_hvt ad=0.16655 pd=1.39 as=0.0567 ps=0.69 w=0.42 l=0.15
X1 X a_59_75# VPWR VPB sky130_fd_pr__pfet_01v8_hvt ad=0.475 pd=2.95 as=0.16655 ps=1.39 w=1 l=0.15
X2 VGND B a_145_75# VNB sky130_fd_pr__nfet_01v8 ad=0.1118 pd=1.04 as=0.0567 ps=0.69 w=0.42 l=0.15
X3 a_59_75# A VPWR VPB sky130_fd_pr__pfet_01v8_hvt ad=0.0567 pd=0.69 as=0.1176 ps=1.4 w=0.42 l=0.15
X4 X a_59_75# VGND VNB sky130_fd_pr__nfet_01v8 ad=0.182 pd=1.86 as=0.1118 ps=1.04 w=0.65 l=0.15
X5 a_145_75# A a_59_75# VNB sky130_fd_pr__nfet_01v8 ad=0.0567 pd=0.69 as=0.1176 ps=1.4 w=0.42 l=0.15
.ends

.subckt lzc16 VDD GND A[15] A[14] A[13] A[12] A[11] A[10] A[9] A[8] A[7] A[6] A[5]
+ A[4] A[3] A[2] A[1] A[0] Y[0] Y[1] Y[4] Y[3] Y[2]
Xx1 x7/A0 x4/A x5/A0 x6/A0 A[15] A[14] A[13] A[12] A[11] A[10] A[9] A[8] GND VDD lzc8
Xx2 x7/A1 x3/B x5/A1 x6/A1 A[7] A[6] A[5] A[4] A[3] A[2] A[1] A[0] GND VDD lzc8
Xx3 x4/A x3/B GND GND VDD VDD x9/B sky130_fd_sc_hd__or2_1
Xx4 x4/A GND GND VDD VDD x8/A sky130_fd_sc_hd__inv_1
Xx5 x5/A0 x5/A1 x8/A GND GND VDD VDD x9/A sky130_fd_sc_hd__mux2_1
Xx6 x6/A0 x6/A1 x8/A GND GND VDD VDD x6/X sky130_fd_sc_hd__mux2_1
Xx7 x7/A0 x7/A1 x8/A GND GND VDD VDD x7/X sky130_fd_sc_hd__mux2_1
Xx8 x8/A x9/B GND GND VDD VDD Y[3] sky130_fd_sc_hd__and2_1
Xx9 x9/A x9/B GND GND VDD VDD Y[0] sky130_fd_sc_hd__and2_1
Xx10 x7/X x9/B GND GND VDD VDD Y[2] sky130_fd_sc_hd__and2_1
Xx11 x6/X x9/B GND GND VDD VDD Y[1] sky130_fd_sc_hd__and2_1
Xx12 x9/B GND GND VDD VDD Y[4] sky130_fd_sc_hd__inv_1
.ends
