* NGSPICE file created from lzc4.ext - technology: sky130A

.subckt lzc4 P1 P0 VDD GND V A[0] A[1] A[2] A[3]
X0 GND.t10 a_541_n3799# a_475_n3773# GND.t9 sky130_fd_pr__nfet_01v8 ad=0.1449 pd=1.11 as=0.0693 ps=0.75 w=0.42 l=0.15
X1 a_1016_n2855# x3.B a_934_n2855# VDD.t16 sky130_fd_pr__pfet_01v8_hvt ad=0.0441 pd=0.63 as=0.1092 ps=1.36 w=0.42 l=0.15
X2 x5.A1 A[1].t0 GND.t33 GND.t32 sky130_fd_pr__nfet_01v8 ad=0.169 pd=1.82 as=0.169 ps=1.82 w=0.65 l=0.15
X3 a_541_n3799# P1.t4 VDD.t21 VDD.t20 sky130_fd_pr__pfet_01v8_hvt ad=0.1176 pd=1.4 as=0.0693 ps=0.75 w=0.42 l=0.15
X4 x5.A1 A[1].t2 VDD.t28 VDD.t27 sky130_fd_pr__pfet_01v8_hvt ad=0.26 pd=2.52 as=0.26 ps=2.52 w=1 l=0.15
X5 P1.t1 x4.A GND.t3 GND.t2 sky130_fd_pr__nfet_01v8 ad=0.169 pd=1.82 as=0.169 ps=1.82 w=0.65 l=0.15
X6 x5.A0 A[3].t0 GND.t27 GND.t26 sky130_fd_pr__nfet_01v8 ad=0.169 pd=1.82 as=0.169 ps=1.82 w=0.65 l=0.15
X7 P1.t0 x4.A VDD.t1 VDD.t0 sky130_fd_pr__pfet_01v8_hvt ad=0.26 pd=2.52 as=0.26 ps=2.52 w=1 l=0.15
X8 a_541_n3799# P1.t2 GND.t21 GND.t20 sky130_fd_pr__nfet_01v8 ad=0.1092 pd=1.36 as=0.1449 ps=1.11 w=0.42 l=0.15
X9 x5.A0 A[3].t2 VDD.t25 VDD.t24 sky130_fd_pr__pfet_01v8_hvt ad=0.26 pd=2.52 as=0.26 ps=2.52 w=1 l=0.15
X10 x3.B a_932_n3523# VDD.t15 VDD.t14 sky130_fd_pr__pfet_01v8_hvt ad=0.34 pd=2.68 as=0.14575 ps=1.335 w=1 l=0.15
X11 x3.B a_932_n3523# GND.t15 GND.t14 sky130_fd_pr__nfet_01v8 ad=0.169 pd=1.82 as=0.10025 ps=0.985 w=0.65 l=0.15
X12 GND.t25 A[3].t1 a_106_n2855# GND.t24 sky130_fd_pr__nfet_01v8 ad=0.10025 pd=0.985 as=0.0567 ps=0.69 w=0.42 l=0.15
X13 V.t0 a_934_n2855# GND.t5 GND.t4 sky130_fd_pr__nfet_01v8 ad=0.169 pd=1.82 as=0.10025 ps=0.985 w=0.65 l=0.15
X14 a_106_n2855# A[2].t0 GND.t19 GND.t18 sky130_fd_pr__nfet_01v8 ad=0.0567 pd=0.69 as=0.1092 ps=1.36 w=0.42 l=0.15
X15 x4.A a_106_n2855# GND.t7 GND.t6 sky130_fd_pr__nfet_01v8 ad=0.169 pd=1.82 as=0.10025 ps=0.985 w=0.65 l=0.15
X16 a_254_n3446# P1.t5 VDD.t19 VDD.t18 sky130_fd_pr__pfet_01v8_hvt ad=0.07665 pd=0.785 as=0.15835 ps=1.395 w=0.42 l=0.15
X17 a_112_n3621# x5.A0 a_254_n3446# VDD.t8 sky130_fd_pr__pfet_01v8_hvt ad=0.1932 pd=1.34 as=0.07665 ps=0.785 w=0.42 l=0.15
X18 VDD.t30 A[1].t3 a_1014_n3523# VDD.t29 sky130_fd_pr__pfet_01v8_hvt ad=0.14575 pd=1.335 as=0.0441 ps=0.63 w=0.42 l=0.15
X19 a_932_n3523# A[0].t0 GND.t29 GND.t28 sky130_fd_pr__nfet_01v8 ad=0.0567 pd=0.69 as=0.1092 ps=1.36 w=0.42 l=0.15
X20 GND.t31 A[1].t1 a_932_n3523# GND.t30 sky130_fd_pr__nfet_01v8 ad=0.10025 pd=0.985 as=0.0567 ps=0.69 w=0.42 l=0.15
X21 VDD.t23 A[3].t3 a_188_n2855# VDD.t22 sky130_fd_pr__pfet_01v8_hvt ad=0.14575 pd=1.335 as=0.0441 ps=0.63 w=0.42 l=0.15
X22 a_934_n2855# x3.B GND.t17 GND.t16 sky130_fd_pr__nfet_01v8 ad=0.0567 pd=0.69 as=0.1092 ps=1.36 w=0.42 l=0.15
X23 GND.t1 x4.A a_934_n2855# GND.t0 sky130_fd_pr__nfet_01v8 ad=0.10025 pd=0.985 as=0.0567 ps=0.69 w=0.42 l=0.15
X24 V.t1 a_934_n2855# VDD.t5 VDD.t4 sky130_fd_pr__pfet_01v8_hvt ad=0.34 pd=2.68 as=0.14575 ps=1.335 w=1 l=0.15
X25 a_571_n3446# x5.A1 a_112_n3621# VDD.t11 sky130_fd_pr__pfet_01v8_hvt ad=0.0441 pd=0.63 as=0.1932 ps=1.34 w=0.42 l=0.15
X26 x4.A a_106_n2855# VDD.t7 VDD.t6 sky130_fd_pr__pfet_01v8_hvt ad=0.34 pd=2.68 as=0.14575 ps=1.335 w=1 l=0.15
X27 VDD.t10 a_541_n3799# a_571_n3446# VDD.t9 sky130_fd_pr__pfet_01v8_hvt ad=0.0693 pd=0.75 as=0.0441 ps=0.63 w=0.42 l=0.15
X28 a_1014_n3523# A[0].t1 a_932_n3523# VDD.t26 sky130_fd_pr__pfet_01v8_hvt ad=0.0441 pd=0.63 as=0.1092 ps=1.36 w=0.42 l=0.15
X29 a_254_n3773# P1.t3 GND.t23 GND.t22 sky130_fd_pr__nfet_01v8 ad=0.0693 pd=0.75 as=0.11285 ps=1.045 w=0.42 l=0.15
X30 a_188_n2855# A[2].t1 a_106_n2855# VDD.t17 sky130_fd_pr__pfet_01v8_hvt ad=0.0441 pd=0.63 as=0.1092 ps=1.36 w=0.42 l=0.15
X31 VDD.t3 x4.A a_1016_n2855# VDD.t2 sky130_fd_pr__pfet_01v8_hvt ad=0.14575 pd=1.335 as=0.0441 ps=0.63 w=0.42 l=0.15
X32 VDD.t13 a_112_n3621# P0.t1 VDD.t12 sky130_fd_pr__pfet_01v8_hvt ad=0.15835 pd=1.395 as=0.26 ps=2.52 w=1 l=0.15
X33 GND.t13 a_112_n3621# P0.t0 GND.t12 sky130_fd_pr__nfet_01v8 ad=0.11285 pd=1.045 as=0.169 ps=1.82 w=0.65 l=0.15
X34 a_475_n3773# x5.A0 a_112_n3621# GND.t8 sky130_fd_pr__nfet_01v8 ad=0.0693 pd=0.75 as=0.09975 ps=0.895 w=0.42 l=0.15
X35 a_112_n3621# x5.A1 a_254_n3773# GND.t11 sky130_fd_pr__nfet_01v8 ad=0.09975 pd=0.895 as=0.0693 ps=0.75 w=0.42 l=0.15
R0 A[0].n0 A[0].t0 192.639
R1 A[0].n1 A[0].n0 155.887
R2 A[0].n0 A[0].t1 134.799
R3 A[0].n2 A[0].n1 9.43628
R4 A[0].n1 A[0] 2.28621
R5 A[0] A[0].n2 0.0571406
R6 A[0].n2 A[0] 0.0306724
R7 P0.n3 P0 593.216
R8 P0.n3 P0.n2 585
R9 P0.n4 P0.n3 585
R10 P0.n1 P0.t0 209.923
R11 P0.n4 P0.n1 74.3207
R12 P0.n3 P0.t1 26.5955
R13 P0.n0 P0 16.2777
R14 P0.n2 P0.n0 6.68707
R15 P0.n2 P0 4.77662
R16 P0 P0.n4 4.77662
R17 P0.n1 P0 2.5103
R18 P0 P0.n0 1.52886
R19 A[1].n0 A[1].t2 230.576
R20 A[1].n2 A[1].t1 206.19
R21 A[1].n0 A[1].t0 158.275
R22 A[1].n1 A[1].n0 154.133
R23 A[1].n3 A[1].n2 152
R24 A[1].n2 A[1].t3 148.35
R25 A[1].n4 A[1].n3 10.7882
R26 A[1].n4 A[1].n1 9.9376
R27 A[1].n5 A[1] 4.61184
R28 A[1].n1 A[1] 4.53383
R29 A[1].n5 A[1].n4 0.781064
R30 A[1].n3 A[1] 0.686214
R31 A[1] A[1].n5 0.0987143
R32 A[1].n5 A[1] 0.0686818
R33 P1.n5 P1.n1 426.658
R34 P1.n0 P1.t2 329.902
R35 P1.n1 P1.t5 272.062
R36 P1.n3 P1.t0 229.548
R37 P1.n1 P1.t3 206.19
R38 P1 P1.t1 152.889
R39 P1 P1.n0 152.674
R40 P1.n0 P1.t4 148.35
R41 P1.n5 P1.n4 19.005
R42 P1.n4 P1.n3 13.839
R43 P1.n3 P1.n2 6.01262
R44 P1.n2 P1 2.22659
R45 P1.n2 P1 1.55202
R46 P1 P1.n5 1.34787
R47 P1.n4 P1 0.664562
R48 V.n0 V.t1 336.281
R49 V V.t0 174.464
R50 V.n0 V 18.1403
R51 V.n1 V.n0 4.30341
R52 V.n1 V 2.4386
R53 V V.n1 1.43601
R54 A[2].n0 A[2].t0 192.639
R55 A[2].n1 A[2].n0 155.887
R56 A[2].n0 A[2].t1 134.799
R57 A[2] A[2].n1 9.46645
R58 A[2].n1 A[2] 2.28621
R59 A[3].n0 A[3].t2 230.576
R60 A[3].n2 A[3].t1 206.19
R61 A[3].n0 A[3].t0 158.275
R62 A[3].n1 A[3].n0 154.133
R63 A[3].n3 A[3].n2 152
R64 A[3].n2 A[3].t3 148.35
R65 A[3].n4 A[3].n3 10.7882
R66 A[3].n4 A[3].n1 9.9376
R67 A[3].n1 A[3] 4.53383
R68 A[3] A[3].n4 0.849246
R69 A[3].n3 A[3] 0.686214
R70 VDD.n51 VDD.t27 766.545
R71 VDD.n12 VDD.t0 766.545
R72 VDD.t11 VDD.t8 633.333
R73 VDD.n67 VDD.n66 629.801
R74 VDD.n11 VDD.t24 553.428
R75 VDD VDD.t14 547.509
R76 VDD VDD.t4 547.509
R77 VDD VDD.t6 547.509
R78 VDD VDD.t20 500.156
R79 VDD.t18 VDD.t12 322.587
R80 VDD.n60 VDD.n48 315.303
R81 VDD.n22 VDD.n8 315.303
R82 VDD.n36 VDD.n2 315.301
R83 VDD.t27 VDD 313.707
R84 VDD.t26 VDD 313.707
R85 VDD.t0 VDD 313.707
R86 VDD.t16 VDD 313.707
R87 VDD.t24 VDD 313.707
R88 VDD.t17 VDD 313.707
R89 VDD.t8 VDD.t18 304.829
R90 VDD.t14 VDD.t29 287.072
R91 VDD.t4 VDD.t2 287.072
R92 VDD.t6 VDD.t22 287.072
R93 VDD.t20 VDD.t9 284.113
R94 VDD.n53 VDD.t28 255.905
R95 VDD.n30 VDD.t25 255.905
R96 VDD.n16 VDD.t1 255.905
R97 VDD.n79 VDD.n41 235.248
R98 VDD VDD.n11 221.964
R99 VDD.n11 VDD.n5 213.119
R100 VDD.t29 VDD.t26 213.084
R101 VDD.t9 VDD.t11 213.084
R102 VDD.t2 VDD.t16 213.084
R103 VDD.t22 VDD.t17 213.084
R104 VDD.n41 VDD.t19 123.507
R105 VDD.n48 VDD.t30 96.1553
R106 VDD.n2 VDD.t23 96.1553
R107 VDD.n8 VDD.t3 96.1553
R108 VDD.n66 VDD.t10 86.7743
R109 VDD.n66 VDD.t21 68.0124
R110 VDD.t12 VDD 59.1905
R111 VDD.n38 VDD.n37 43.9358
R112 VDD.n80 VDD.n79 43.1829
R113 VDD.n64 VDD.n46 34.6358
R114 VDD.n65 VDD.n64 34.6358
R115 VDD.n68 VDD.n65 34.6358
R116 VDD.n72 VDD.n44 34.6358
R117 VDD.n73 VDD.n72 34.6358
R118 VDD.n74 VDD.n73 34.6358
R119 VDD.n74 VDD.n42 34.6358
R120 VDD.n78 VDD.n42 34.6358
R121 VDD.n58 VDD.n49 34.6358
R122 VDD.n59 VDD.n58 34.6358
R123 VDD.n54 VDD.n52 34.6358
R124 VDD.n31 VDD.n3 34.6358
R125 VDD.n35 VDD.n3 34.6358
R126 VDD.n29 VDD.n28 34.6358
R127 VDD.n24 VDD.n23 34.6358
R128 VDD.n17 VDD.n9 34.6358
R129 VDD.n21 VDD.n9 34.6358
R130 VDD.n15 VDD.n14 34.6358
R131 VDD.n60 VDD.n46 34.2593
R132 VDD.n37 VDD.n36 34.2593
R133 VDD.n23 VDD.n22 34.2593
R134 VDD.n41 VDD.t13 28.752
R135 VDD.n48 VDD.t15 25.6105
R136 VDD.n2 VDD.t7 25.6105
R137 VDD.n8 VDD.t5 25.6105
R138 VDD.n52 VDD.n51 23.7181
R139 VDD.n28 VDD.n5 23.7181
R140 VDD.n24 VDD.n5 23.7181
R141 VDD.n14 VDD.n12 23.7181
R142 VDD.n68 VDD.n67 17.3181
R143 VDD.n67 VDD.n44 17.3181
R144 VDD.n40 VDD.n39 16.2708
R145 VDD.n54 VDD.n53 10.5417
R146 VDD.n30 VDD.n29 10.5417
R147 VDD.n16 VDD.n15 10.5417
R148 VDD.n60 VDD.n59 10.1652
R149 VDD.n36 VDD.n35 10.1652
R150 VDD.n22 VDD.n21 10.1652
R151 VDD VDD.n12 9.33175
R152 VDD.n51 VDD 9.33175
R153 VDD.n14 VDD.n13 9.3005
R154 VDD.n15 VDD.n10 9.3005
R155 VDD.n18 VDD.n17 9.3005
R156 VDD.n19 VDD.n9 9.3005
R157 VDD.n21 VDD.n20 9.3005
R158 VDD.n22 VDD.n7 9.3005
R159 VDD.n23 VDD.n6 9.3005
R160 VDD.n25 VDD.n24 9.3005
R161 VDD.n26 VDD.n5 9.3005
R162 VDD.n28 VDD.n27 9.3005
R163 VDD.n29 VDD.n4 9.3005
R164 VDD.n32 VDD.n31 9.3005
R165 VDD.n33 VDD.n3 9.3005
R166 VDD.n35 VDD.n34 9.3005
R167 VDD.n36 VDD.n1 9.3005
R168 VDD.n37 VDD.n0 9.3005
R169 VDD.n52 VDD.n50 9.3005
R170 VDD.n55 VDD.n54 9.3005
R171 VDD.n56 VDD.n49 9.3005
R172 VDD.n58 VDD.n57 9.3005
R173 VDD.n59 VDD.n47 9.3005
R174 VDD.n61 VDD.n60 9.3005
R175 VDD.n62 VDD.n46 9.3005
R176 VDD.n64 VDD.n63 9.3005
R177 VDD.n65 VDD.n45 9.3005
R178 VDD.n69 VDD.n68 9.3005
R179 VDD.n70 VDD.n44 9.3005
R180 VDD.n72 VDD.n71 9.3005
R181 VDD.n73 VDD.n43 9.3005
R182 VDD.n75 VDD.n74 9.3005
R183 VDD.n76 VDD.n42 9.3005
R184 VDD.n78 VDD.n77 9.3005
R185 VDD.n53 VDD.n49 8.28285
R186 VDD.n31 VDD.n30 8.28285
R187 VDD.n17 VDD.n16 8.28285
R188 VDD.n79 VDD.n78 0.753441
R189 VDD.n13 VDD.n10 0.120292
R190 VDD.n18 VDD.n10 0.120292
R191 VDD.n20 VDD.n19 0.120292
R192 VDD.n20 VDD.n7 0.120292
R193 VDD.n7 VDD.n6 0.120292
R194 VDD.n25 VDD.n6 0.120292
R195 VDD.n27 VDD.n4 0.120292
R196 VDD.n32 VDD.n4 0.120292
R197 VDD.n34 VDD.n33 0.120292
R198 VDD.n34 VDD.n1 0.120292
R199 VDD.n1 VDD.n0 0.120292
R200 VDD.n55 VDD.n50 0.120292
R201 VDD.n56 VDD.n55 0.120292
R202 VDD.n57 VDD.n47 0.120292
R203 VDD.n61 VDD.n47 0.120292
R204 VDD.n62 VDD.n61 0.120292
R205 VDD.n63 VDD.n62 0.120292
R206 VDD.n69 VDD.n45 0.120292
R207 VDD.n70 VDD.n69 0.120292
R208 VDD.n71 VDD.n70 0.120292
R209 VDD.n71 VDD.n43 0.120292
R210 VDD.n75 VDD.n43 0.120292
R211 VDD.n76 VDD.n75 0.120292
R212 VDD.n77 VDD.n76 0.120292
R213 VDD.n80 VDD.n40 0.0734167
R214 VDD.n13 VDD 0.0603958
R215 VDD.n19 VDD 0.0603958
R216 VDD.n26 VDD 0.0603958
R217 VDD.n27 VDD 0.0603958
R218 VDD.n33 VDD 0.0603958
R219 VDD.n39 VDD.n0 0.0603958
R220 VDD.n39 VDD.n38 0.0603958
R221 VDD VDD.n50 0.0603958
R222 VDD.n57 VDD 0.0603958
R223 VDD VDD.n45 0.0603958
R224 VDD.n77 VDD.n40 0.047375
R225 VDD VDD.n26 0.03175
R226 VDD VDD.n18 0.0226354
R227 VDD VDD.n25 0.0226354
R228 VDD VDD.n32 0.0226354
R229 VDD.n38 VDD 0.0226354
R230 VDD VDD.n56 0.0226354
R231 VDD.n63 VDD 0.0226354
R232 VDD VDD.n80 0.0213333
R233 GND.n45 GND.n44 818539
R234 GND.n44 GND 32781.8
R235 GND.n45 GND.n43 26816.2
R236 GND.t32 GND.n43 2662.78
R237 GND.t14 GND 2634.3
R238 GND.t20 GND 2406.47
R239 GND.t9 GND.t20 2392.23
R240 GND.n46 GND.t2 2371.18
R241 GND.t26 GND.n7 2371.18
R242 GND GND.t4 2345.82
R243 GND.t6 GND 2345.82
R244 GND.t11 GND.t8 1779.94
R245 GND.t12 GND.t22 1552.1
R246 GND GND.t32 1509.39
R247 GND.n46 GND.n45 1394.81
R248 GND.t30 GND.t14 1381.23
R249 GND.t8 GND.t9 1366.99
R250 GND.t22 GND.t11 1366.99
R251 GND.t2 GND 1344.09
R252 GND GND.t26 1344.09
R253 GND GND.t28 1338.51
R254 GND.t4 GND.t0 1229.97
R255 GND.t24 GND.t6 1229.97
R256 GND.n47 GND.n46 1198.25
R257 GND.n43 GND.n42 1198.25
R258 GND.n65 GND.n7 1198.25
R259 GND.t28 GND.t30 1196.12
R260 GND.t16 GND 1191.93
R261 GND GND.t18 1191.93
R262 GND.n44 GND 1153.89
R263 GND.t0 GND.t16 1065.13
R264 GND.t18 GND.t24 1065.13
R265 GND GND.n7 951.01
R266 GND.n30 GND.t29 246.506
R267 GND.n60 GND.t17 246.506
R268 GND.n73 GND.t19 246.506
R269 GND.n16 GND.n15 210.601
R270 GND.n58 GND.n57 210.601
R271 GND.n78 GND.n71 210.601
R272 GND.n89 GND.n88 199.739
R273 GND.n22 GND.n21 185
R274 GND.n24 GND.n23 185
R275 GND.n38 GND.t33 158.361
R276 GND.n51 GND.t3 158.361
R277 GND.n4 GND.t27 158.361
R278 GND GND.t12 142.395
R279 GND.n23 GND.n22 97.1434
R280 GND.n88 GND.t23 74.2862
R281 GND.n22 GND.t10 61.4291
R282 GND.n15 GND.t31 55.7148
R283 GND.n57 GND.t1 55.7148
R284 GND.n71 GND.t25 55.7148
R285 GND.n23 GND.t21 38.5719
R286 GND.n39 GND.n11 34.6358
R287 GND.n37 GND.n36 34.6358
R288 GND.n36 GND.n13 34.6358
R289 GND.n32 GND.n31 34.6358
R290 GND.n29 GND.n17 34.6358
R291 GND.n25 GND.n17 34.6358
R292 GND.n20 GND.n1 34.6358
R293 GND.n86 GND.n1 34.6358
R294 GND.n87 GND.n86 34.6358
R295 GND.n50 GND.n49 34.6358
R296 GND.n52 GND.n9 34.6358
R297 GND.n56 GND.n9 34.6358
R298 GND.n61 GND.n59 34.6358
R299 GND.n67 GND.n66 34.6358
R300 GND.n80 GND.n70 34.6358
R301 GND.n80 GND.n79 34.6358
R302 GND.n77 GND.n72 34.6358
R303 GND.n15 GND.t15 26.8576
R304 GND.n57 GND.t5 26.8576
R305 GND.n71 GND.t7 26.8576
R306 GND.n88 GND.t13 25.4291
R307 GND.n42 GND.n11 23.7181
R308 GND.n49 GND.n47 23.7181
R309 GND.n65 GND.n6 23.7181
R310 GND.n66 GND.n65 23.7181
R311 GND.n89 GND.n87 22.9652
R312 GND.n21 GND.n20 22.2496
R313 GND.n83 GND.n82 16.1899
R314 GND.n16 GND.n13 16.1887
R315 GND.n58 GND.n56 16.1887
R316 GND.n79 GND.n78 16.1887
R317 GND.n31 GND.n30 15.0593
R318 GND.n61 GND.n60 15.0593
R319 GND.n73 GND.n72 15.0593
R320 GND.n25 GND.n24 11.7085
R321 GND.n74 GND.n73 10.8064
R322 GND.n39 GND.n38 10.5417
R323 GND.n51 GND.n50 10.5417
R324 GND.n67 GND.n4 10.5417
R325 GND GND.n47 9.33305
R326 GND.n42 GND 9.33305
R327 GND.n75 GND.n72 9.3005
R328 GND.n77 GND.n76 9.3005
R329 GND.n79 GND.n3 9.3005
R330 GND.n81 GND.n80 9.3005
R331 GND.n70 GND.n69 9.3005
R332 GND.n49 GND.n48 9.3005
R333 GND.n50 GND.n10 9.3005
R334 GND.n53 GND.n52 9.3005
R335 GND.n54 GND.n9 9.3005
R336 GND.n56 GND.n55 9.3005
R337 GND.n59 GND.n8 9.3005
R338 GND.n62 GND.n61 9.3005
R339 GND.n63 GND.n6 9.3005
R340 GND.n65 GND.n64 9.3005
R341 GND.n66 GND.n5 9.3005
R342 GND.n68 GND.n67 9.3005
R343 GND.n87 GND.n0 9.3005
R344 GND.n86 GND.n85 9.3005
R345 GND.n84 GND.n1 9.3005
R346 GND.n20 GND.n2 9.3005
R347 GND.n19 GND.n18 9.3005
R348 GND.n26 GND.n25 9.3005
R349 GND.n27 GND.n17 9.3005
R350 GND.n29 GND.n28 9.3005
R351 GND.n31 GND.n14 9.3005
R352 GND.n33 GND.n32 9.3005
R353 GND.n34 GND.n13 9.3005
R354 GND.n36 GND.n35 9.3005
R355 GND.n37 GND.n12 9.3005
R356 GND.n41 GND.n11 9.3005
R357 GND.n40 GND.n39 9.3005
R358 GND.n90 GND.n89 7.12063
R359 GND.n38 GND.n37 6.77697
R360 GND.n52 GND.n51 6.77697
R361 GND.n70 GND.n4 6.77697
R362 GND.n24 GND.n19 4.35795
R363 GND.n32 GND.n16 2.25932
R364 GND.n59 GND.n58 2.25932
R365 GND.n78 GND.n77 2.25932
R366 GND.n21 GND.n19 1.8161
R367 GND.n30 GND.n29 1.50638
R368 GND.n60 GND.n6 1.50638
R369 GND.n90 GND.n0 0.148519
R370 GND.n48 GND.n10 0.120292
R371 GND.n53 GND.n10 0.120292
R372 GND.n55 GND.n54 0.120292
R373 GND.n55 GND.n8 0.120292
R374 GND.n62 GND.n8 0.120292
R375 GND.n63 GND.n62 0.120292
R376 GND.n68 GND.n5 0.120292
R377 GND.n69 GND.n68 0.120292
R378 GND.n81 GND.n3 0.120292
R379 GND.n76 GND.n3 0.120292
R380 GND.n76 GND.n75 0.120292
R381 GND.n75 GND.n74 0.120292
R382 GND.n41 GND.n40 0.120292
R383 GND.n40 GND.n12 0.120292
R384 GND.n35 GND.n34 0.120292
R385 GND.n34 GND.n33 0.120292
R386 GND.n33 GND.n14 0.120292
R387 GND.n28 GND.n14 0.120292
R388 GND.n27 GND.n26 0.120292
R389 GND.n26 GND.n18 0.120292
R390 GND.n18 GND.n2 0.120292
R391 GND.n85 GND.n84 0.120292
R392 GND.n85 GND.n0 0.120292
R393 GND GND.n90 0.11354
R394 GND.n83 GND.n2 0.0616979
R395 GND.n48 GND 0.0603958
R396 GND.n54 GND 0.0603958
R397 GND.n64 GND 0.0603958
R398 GND GND.n5 0.0603958
R399 GND GND.n41 0.0603958
R400 GND.n35 GND 0.0603958
R401 GND GND.n27 0.0603958
R402 GND.n84 GND.n83 0.0590938
R403 GND.n82 GND.n81 0.0577917
R404 GND.n64 GND 0.0330521
R405 GND GND.n53 0.0226354
R406 GND GND.n63 0.0226354
R407 GND.n69 GND 0.0226354
R408 GND.n74 GND 0.0226354
R409 GND GND.n12 0.0226354
R410 GND.n28 GND 0.0226354
R411 GND.n82 GND 0.00310417
C0 x5.A1 a_541_n3799# 0.12552f
C1 x4.A V 0.24568f
C2 x5.A0 A[1] 0.10783f
C3 A[0] x5.A1 0.17934f
C4 P1 a_112_n3621# 0.31896f
C5 x5.A0 P1 0.10746f
C6 x3.B VDD 0.50378f
C7 x3.B A[1] 0.11669f
C8 a_932_n3523# x3.B 0.11079f
C9 x5.A1 a_112_n3621# 0.1899f
C10 P1 x3.B 0.23291f
C11 A[0] a_541_n3799# 0.12169f
C12 x5.A0 x5.A1 0.31199f
C13 P0 VDD 1.03083f
C14 A[2] a_106_n2855# 0.10291f
C15 A[3] x4.A 0.1498f
C16 P0 A[1] 0.77242f
C17 x3.B a_934_n2855# 0.12167f
C18 P1 P0 0.1847f
C19 x4.A x3.B 0.31623f
C20 A[3] x5.A0 0.12736f
C21 A[1] VDD 0.21139f
C22 a_932_n3523# VDD 0.14345f
C23 a_106_n2855# VDD 0.16289f
C24 a_932_n3523# A[1] 0.26232f
C25 P1 VDD 0.98844f
C26 P1 A[1] 0.27127f
C27 a_934_n2855# VDD 0.1779f
C28 A[3] A[2] 0.15665f
C29 x5.A1 VDD 0.26825f
C30 V VDD 0.34887f
C31 x5.A1 A[1] 0.20574f
C32 P0 a_112_n3621# 0.11064f
C33 P1 x5.A1 0.46533f
C34 x4.A VDD 0.67179f
C35 VDD a_541_n3799# 0.15862f
C36 x4.A a_106_n2855# 0.10959f
C37 x4.A P1 0.13222f
C38 V a_934_n2855# 0.11059f
C39 P0 x3.B 0.18755f
C40 A[0] A[1] 0.34757f
C41 A[0] a_932_n3523# 0.10682f
C42 A[3] VDD 0.34446f
C43 P1 a_541_n3799# 0.22021f
C44 A[3] a_106_n2855# 0.27118f
C45 x4.A a_934_n2855# 0.23286f
C46 x5.A0 VDD 0.56919f
C47 A[0] GND 1.3076f
C48 P0 GND 1.61176f
C49 A[1] GND 0.91206f
C50 P1 GND 1.11367f
C51 V GND 0.88225f
C52 A[2] GND 0.35924f
C53 A[3] GND 0.58074f
C54 VDD GND 7.15351f
C55 a_541_n3799# GND 0.26672f
C56 x5.A1 GND 0.80184f
C57 a_932_n3523# GND 0.20114f
C58 a_112_n3621# GND 0.24744f
C59 x3.B GND 0.79282f
C60 x5.A0 GND 0.9033f
C61 x4.A GND 0.86026f
C62 a_934_n2855# GND 0.20331f
C63 a_106_n2855# GND 0.21698f
C64 VDD.t6 GND 0.14414f
C65 VDD.t24 GND 0.14976f
C66 VDD.n11 GND 0.14945f
C67 VDD.t4 GND 0.14414f
C68 VDD.t0 GND 0.20453f
C69 VDD.n12 GND 0.19658f
C70 VDD.n39 GND 0.12696f
C71 VDD.n40 GND 0.12776f
C72 VDD.t18 GND 0.10836f
C73 VDD.t8 GND 0.16203f
C74 VDD.t11 GND 0.14618f
C75 VDD.t20 GND 0.13545f
C76 VDD.t14 GND 0.14414f
C77 VDD.t27 GND 0.20453f
C78 VDD.n51 GND 0.19658f
C79 A[3].n0 GND 0.11855f
C80 A[3].n4 GND 0.46066f
C81 A[2].n0 GND 0.11257f
C82 V.n0 GND 0.12867f
C83 P1.n0 GND 0.10846f
C84 P1.n1 GND 0.25857f
C85 P1.t0 GND 0.15942f
C86 P1.t1 GND 0.10716f
C87 P1.n3 GND 0.22463f
C88 P1.n4 GND 1.15647f
C89 P1.n5 GND 0.53371f
C90 A[1].t2 GND 0.10193f
C91 A[1].n0 GND 0.19131f
C92 A[1].n2 GND 0.12679f
C93 A[1].n4 GND 0.7303f
C94 A[1].n5 GND 0.5337f
C95 P0.n0 GND 0.40973f
C96 P0.t0 GND 0.14369f
C97 P0.n1 GND 0.14038f
C98 P0.n3 GND 0.18045f
C99 P0.n4 GND 0.13979f
C100 A[0].n0 GND 0.14894f
C101 A[0].n1 GND 0.11415f
C102 A[0].n2 GND 0.14253f
.ends
