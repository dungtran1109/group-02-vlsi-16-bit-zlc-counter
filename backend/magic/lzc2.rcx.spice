* NGSPICE file created from lzc2.ext - technology: sky130A

.subckt lzc2 GND VDD LO HI P V
X0 VDD.t3 HI.t3 a_150_n903# VDD.t2 sky130_fd_pr__pfet_01v8_hvt ad=0.14575 pd=1.335 as=0.0441 ps=0.63 w=0.42 l=0.15
X1 V.t0 a_68_n903# VDD.t1 VDD.t0 sky130_fd_pr__pfet_01v8_hvt ad=0.34 pd=2.68 as=0.14575 ps=1.335 w=1 l=0.15
X2 GND.t3 HI.t1 a_68_n903# GND.t2 sky130_fd_pr__nfet_01v8 ad=0.10025 pd=0.985 as=0.0567 ps=0.69 w=0.42 l=0.15
X3 V.t1 a_68_n903# GND.t1 GND.t0 sky130_fd_pr__nfet_01v8 ad=0.169 pd=1.82 as=0.10025 ps=0.985 w=0.65 l=0.15
X4 a_150_n903# LO.t1 a_68_n903# VDD.t6 sky130_fd_pr__pfet_01v8_hvt ad=0.0441 pd=0.63 as=0.1092 ps=1.36 w=0.42 l=0.15
X5 a_68_n903# LO.t0 GND.t7 GND.t6 sky130_fd_pr__nfet_01v8 ad=0.0567 pd=0.69 as=0.1092 ps=1.36 w=0.42 l=0.15
X6 P.t0 HI.t0 GND.t5 GND.t4 sky130_fd_pr__nfet_01v8 ad=0.169 pd=1.82 as=0.169 ps=1.82 w=0.65 l=0.15
X7 P.t1 HI.t2 VDD.t5 VDD.t4 sky130_fd_pr__pfet_01v8_hvt ad=0.26 pd=2.52 as=0.26 ps=2.52 w=1 l=0.15
R0 P.n0 P.t1 235.56
R1 P.n1 P.t0 134.828
R2 P P.n1 18.0612
R3 P.n1 P 14.1681
R4 P P.n0 2.22659
R5 P.n0 P 1.55202
R6 V.n0 V.t0 336.163
R7 V V.t1 174.464
R8 V.n0 V 18.2155
R9 V.n1 V.n0 4.42221
R10 V.n1 V 2.4386
R11 V V.n1 1.43601
R12 LO.n0 LO.t0 192.639
R13 LO.n1 LO.n0 155.887
R14 LO.n0 LO.t1 134.799
R15 LO.n1 LO 9.46645
R16 LO LO.n1 2.28621
R17 HI.n0 HI.t2 230.576
R18 HI.n1 HI.t1 206.19
R19 HI.n0 HI.t0 158.275
R20 HI.n4 HI.n0 154.133
R21 HI.n2 HI.n1 152
R22 HI.n1 HI.t3 148.35
R23 HI.n3 HI.n2 10.7882
R24 HI.n4 HI.n3 9.9376
R25 HI HI.n4 4.53383
R26 HI.n3 HI 0.849246
R27 HI.n2 HI 0.686214
R28 VDD.n3 VDD.t4 766.545
R29 VDD VDD.t0 547.509
R30 VDD.n11 VDD.n10 315.301
R31 VDD.t4 VDD 313.707
R32 VDD.t6 VDD 313.707
R33 VDD.t0 VDD.t2 287.072
R34 VDD.n7 VDD.t5 255.905
R35 VDD.t2 VDD.t6 213.084
R36 VDD.n10 VDD.t3 96.1553
R37 VDD.n13 VDD.n8 34.6358
R38 VDD.n13 VDD.n12 34.6358
R39 VDD.n6 VDD.n2 34.6358
R40 VDD.n10 VDD.t1 25.6105
R41 VDD.n3 VDD.n2 23.7181
R42 VDD.n7 VDD.n6 10.5417
R43 VDD.n12 VDD.n11 10.1652
R44 VDD VDD.n3 9.33175
R45 VDD.n4 VDD.n2 9.3005
R46 VDD.n6 VDD.n5 9.3005
R47 VDD.n8 VDD.n0 9.3005
R48 VDD.n14 VDD.n13 9.3005
R49 VDD.n12 VDD.n1 9.3005
R50 VDD.n8 VDD.n7 8.28285
R51 VDD.n11 VDD.n9 7.5914
R52 VDD.n9 VDD 0.237498
R53 VDD.n9 VDD.n1 0.146355
R54 VDD.n5 VDD.n4 0.120292
R55 VDD.n5 VDD.n0 0.120292
R56 VDD.n14 VDD.n1 0.120292
R57 VDD.n4 VDD 0.0603958
R58 VDD VDD.n14 0.0603958
R59 VDD VDD.n0 0.0226354
R60 GND.n3 GND.t4 3861.03
R61 GND GND.t0 2634.3
R62 GND.t4 GND 1509.39
R63 GND.t0 GND.t2 1381.23
R64 GND.t6 GND 1338.51
R65 GND.t2 GND.t6 1196.12
R66 GND.n11 GND.t7 246.506
R67 GND.n16 GND.n9 210.601
R68 GND.n7 GND.t5 158.361
R69 GND.n9 GND.t3 55.7148
R70 GND.n6 GND.n2 34.6358
R71 GND.n18 GND.n8 34.6358
R72 GND.n18 GND.n17 34.6358
R73 GND.n15 GND.n10 34.6358
R74 GND.n9 GND.t1 26.8576
R75 GND.n3 GND.n2 23.7181
R76 GND.n17 GND.n16 16.1887
R77 GND.n11 GND.n10 15.0593
R78 GND.n12 GND.n11 10.8064
R79 GND.n7 GND.n6 10.5417
R80 GND GND.n3 9.33305
R81 GND.n13 GND.n10 9.3005
R82 GND.n15 GND.n14 9.3005
R83 GND.n17 GND.n1 9.3005
R84 GND.n19 GND.n18 9.3005
R85 GND.n8 GND.n0 9.3005
R86 GND.n4 GND.n2 9.3005
R87 GND.n6 GND.n5 9.3005
R88 GND.n8 GND.n7 6.77697
R89 GND.n16 GND.n15 2.25932
R90 GND.n5 GND.n4 0.120292
R91 GND.n5 GND.n0 0.120292
R92 GND.n19 GND.n1 0.120292
R93 GND.n14 GND.n1 0.120292
R94 GND.n14 GND.n13 0.120292
R95 GND.n13 GND.n12 0.120292
R96 GND.n4 GND 0.0603958
R97 GND GND.n19 0.0603958
R98 GND GND.n0 0.0226354
R99 GND.n12 GND 0.0226354
C0 V HI 0.14821f
C1 P VDD 0.21015f
C2 a_68_n903# VDD 0.14627f
C3 V VDD 0.34013f
C4 HI LO 0.14148f
C5 VDD HI 0.29914f
C6 V a_68_n903# 0.10871f
C7 a_68_n903# LO 0.10286f
C8 a_68_n903# HI 0.27035f
C9 P GND 0.43043f
C10 V GND 0.84421f
C11 LO GND 0.31747f
C12 HI GND 0.54757f
C13 VDD GND 1.60211f
C14 a_68_n903# GND 0.22281f
C15 VDD.t0 GND 0.10389f
C16 VDD.t4 GND 0.14743f
C17 VDD.n3 GND 0.1417f
C18 HI.n0 GND 0.10276f
C19 HI.n3 GND 0.3993f
.ends
