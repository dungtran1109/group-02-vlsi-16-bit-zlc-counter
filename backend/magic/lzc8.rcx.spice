* NGSPICE file created from lzc8.ext - technology: sky130A

.subckt lzc8 P2 V P0 P1 VDD GND A[7] A[6] A[5] A[4] A[3] A[2] A[1] A[0]
X0 x1.x4.A a_n2628_n2249# GND.t58 GND.t57 sky130_fd_pr__nfet_01v8 ad=0.169 pd=1.82 as=0.10025 ps=0.985 w=0.65 l=0.15
X1 x1.x4.A a_n2628_n2249# VDD.t56 VDD.t55 sky130_fd_pr__pfet_01v8_hvt ad=0.34 pd=2.68 as=0.14575 ps=1.335 w=1 l=0.15
X2 VDD.t1 a_n2622_n3015# x6.A1 VDD.t0 sky130_fd_pr__pfet_01v8_hvt ad=0.15835 pd=1.395 as=0.26 ps=2.52 w=1 l=0.15
X3 a_n1658_n1563# A[4].t1 a_n1740_n1563# VDD.t87 sky130_fd_pr__pfet_01v8_hvt ad=0.0441 pd=0.63 as=0.1092 ps=1.36 w=0.42 l=0.15
X4 a_n2163_n2840# x1.x5.A1 a_n2622_n3015# VDD.t39 sky130_fd_pr__pfet_01v8_hvt ad=0.0441 pd=0.63 as=0.1932 ps=1.34 w=0.42 l=0.15
X5 GND.t1 a_n2622_n3015# x6.A1 GND.t0 sky130_fd_pr__nfet_01v8 ad=0.11285 pd=1.045 as=0.169 ps=1.82 w=0.65 l=0.15
X6 GND.t81 A[5].t1 a_n1740_n1563# GND.t80 sky130_fd_pr__nfet_01v8 ad=0.10025 pd=0.985 as=0.0567 ps=0.69 w=0.42 l=0.15
X7 a_n964_n2347# x5.A0 a_n822_n2172# VDD.t46 sky130_fd_pr__pfet_01v8_hvt ad=0.1932 pd=1.34 as=0.07665 ps=0.785 w=0.42 l=0.15
X8 a_n1656_n895# x2.x3.B a_n1738_n895# VDD.t52 sky130_fd_pr__pfet_01v8_hvt ad=0.0441 pd=0.63 as=0.1092 ps=1.36 w=0.42 l=0.15
X9 a_n2480_n3167# x5.A1 GND.t24 GND.t23 sky130_fd_pr__nfet_01v8 ad=0.0693 pd=0.75 as=0.11285 ps=1.045 w=0.42 l=0.15
X10 x5.A0 x2.x4.A GND.t5 GND.t4 sky130_fd_pr__nfet_01v8 ad=0.169 pd=1.82 as=0.169 ps=1.82 w=0.65 l=0.15
X11 VDD.t49 a_n2560_n1661# x6.A0 VDD.t48 sky130_fd_pr__pfet_01v8_hvt ad=0.15835 pd=1.395 as=0.26 ps=2.52 w=1 l=0.15
X12 GND.t32 x4.A a_n910_n895# GND.t31 sky130_fd_pr__nfet_01v8 ad=0.10025 pd=0.985 as=0.0567 ps=0.69 w=0.42 l=0.15
X13 x2.x5.A0 A[7].t0 GND.t69 GND.t68 sky130_fd_pr__nfet_01v8 ad=0.169 pd=1.82 as=0.169 ps=1.82 w=0.65 l=0.15
X14 GND.t12 a_n812_n1661# P0.t1 GND.t11 sky130_fd_pr__nfet_01v8 ad=0.11285 pd=1.045 as=0.169 ps=1.82 w=0.65 l=0.15
X15 x4.A a_n1738_n895# VDD.t41 VDD.t40 sky130_fd_pr__pfet_01v8_hvt ad=0.34 pd=2.68 as=0.14575 ps=1.335 w=1 l=0.15
X16 x2.x4.A a_n2566_n895# VDD.t38 VDD.t37 sky130_fd_pr__pfet_01v8_hvt ad=0.34 pd=2.68 as=0.14575 ps=1.335 w=1 l=0.15
X17 VDD.t32 x4.A a_n828_n895# VDD.t31 sky130_fd_pr__pfet_01v8_hvt ad=0.14575 pd=1.335 as=0.0441 ps=0.63 w=0.42 l=0.15
X18 a_n2193_n3193# x5.A1 VDD.t24 VDD.t23 sky130_fd_pr__pfet_01v8_hvt ad=0.1176 pd=1.4 as=0.0693 ps=0.75 w=0.42 l=0.15
X19 x2.x3.B a_n1740_n1563# GND.t56 GND.t55 sky130_fd_pr__nfet_01v8 ad=0.169 pd=1.82 as=0.10025 ps=0.985 w=0.65 l=0.15
X20 x1.x5.A0 A[3].t0 GND.t89 GND.t88 sky130_fd_pr__nfet_01v8 ad=0.169 pd=1.82 as=0.169 ps=1.82 w=0.65 l=0.15
X21 x1.x5.A0 A[3].t2 VDD.t84 VDD.t83 sky130_fd_pr__pfet_01v8_hvt ad=0.26 pd=2.52 as=0.26 ps=2.52 w=1 l=0.15
X22 VDD.t75 A[5].t3 a_n1658_n1563# VDD.t74 sky130_fd_pr__pfet_01v8_hvt ad=0.14575 pd=1.335 as=0.0441 ps=0.63 w=0.42 l=0.15
X23 V.t1 a_n910_n895# GND.t36 GND.t35 sky130_fd_pr__nfet_01v8 ad=0.169 pd=1.82 as=0.10025 ps=0.985 w=0.65 l=0.15
X24 a_n910_n895# x3.B GND.t48 GND.t47 sky130_fd_pr__nfet_01v8 ad=0.0567 pd=0.69 as=0.1092 ps=1.36 w=0.42 l=0.15
X25 VDD.t61 a_n2193_n3193# a_n2163_n2840# VDD.t60 sky130_fd_pr__pfet_01v8_hvt ad=0.0693 pd=0.75 as=0.0441 ps=0.63 w=0.42 l=0.15
X26 GND.t65 a_n2193_n3193# a_n2259_n3167# GND.t64 sky130_fd_pr__nfet_01v8 ad=0.1449 pd=1.11 as=0.0693 ps=0.75 w=0.42 l=0.15
X27 a_n828_n895# x3.B a_n910_n895# VDD.t47 sky130_fd_pr__pfet_01v8_hvt ad=0.0441 pd=0.63 as=0.1092 ps=1.36 w=0.42 l=0.15
X28 P2.t0 x4.A VDD.t34 VDD.t33 sky130_fd_pr__pfet_01v8_hvt ad=0.26 pd=2.52 as=0.26 ps=2.52 w=1 l=0.15
X29 GND.t17 x1.x4.A a_n1800_n2249# GND.t16 sky130_fd_pr__nfet_01v8 ad=0.10025 pd=0.985 as=0.0567 ps=0.69 w=0.42 l=0.15
X30 x1.x5.A1 A[1].t2 VDD.t79 VDD.t78 sky130_fd_pr__pfet_01v8_hvt ad=0.26 pd=2.52 as=0.26 ps=2.52 w=1 l=0.15
X31 VDD.t19 x1.x4.A a_n1718_n2249# VDD.t18 sky130_fd_pr__pfet_01v8_hvt ad=0.14575 pd=1.335 as=0.0441 ps=0.63 w=0.42 l=0.15
X32 VDD.t12 a_n812_n1661# P0.t0 VDD.t11 sky130_fd_pr__pfet_01v8_hvt ad=0.15835 pd=1.395 as=0.26 ps=2.52 w=1 l=0.15
X33 a_n353_n1486# x6.A1 a_n812_n1661# VDD.t13 sky130_fd_pr__pfet_01v8_hvt ad=0.0441 pd=0.63 as=0.1932 ps=1.34 w=0.42 l=0.15
X34 x1.x5.A1 A[1].t0 GND.t85 GND.t84 sky130_fd_pr__nfet_01v8 ad=0.169 pd=1.82 as=0.169 ps=1.82 w=0.65 l=0.15
X35 a_n1718_n2249# x1.x3.B a_n1800_n2249# VDD.t57 sky130_fd_pr__pfet_01v8_hvt ad=0.0441 pd=0.63 as=0.1092 ps=1.36 w=0.42 l=0.15
X36 a_n2131_n1839# x5.A0 VDD.t45 VDD.t44 sky130_fd_pr__pfet_01v8_hvt ad=0.1176 pd=1.4 as=0.0693 ps=0.75 w=0.42 l=0.15
X37 a_n1738_n895# x2.x3.B GND.t54 GND.t53 sky130_fd_pr__nfet_01v8 ad=0.0567 pd=0.69 as=0.1092 ps=1.36 w=0.42 l=0.15
X38 a_n2546_n2249# A[2].t1 a_n2628_n2249# VDD.t82 sky130_fd_pr__pfet_01v8_hvt ad=0.0441 pd=0.63 as=0.1092 ps=1.36 w=0.42 l=0.15
X39 GND.t52 a_n383_n1839# a_n449_n1813# GND.t51 sky130_fd_pr__nfet_01v8 ad=0.1449 pd=1.11 as=0.0693 ps=0.75 w=0.42 l=0.15
X40 a_n2131_n1839# x5.A0 GND.t43 GND.t42 sky130_fd_pr__nfet_01v8 ad=0.1092 pd=1.36 as=0.1449 ps=1.11 w=0.42 l=0.15
X41 a_n2101_n1486# x2.x5.A1 a_n2560_n1661# VDD.t9 sky130_fd_pr__pfet_01v8_hvt ad=0.0441 pd=0.63 as=0.1932 ps=1.34 w=0.42 l=0.15
X42 GND.t8 a_n2131_n1839# a_n2197_n1813# GND.t7 sky130_fd_pr__nfet_01v8 ad=0.1449 pd=1.11 as=0.0693 ps=0.75 w=0.42 l=0.15
X43 x2.x3.B a_n1740_n1563# VDD.t54 VDD.t53 sky130_fd_pr__pfet_01v8_hvt ad=0.34 pd=2.68 as=0.14575 ps=1.335 w=1 l=0.15
X44 a_n535_n2525# P2.t2 GND.t75 GND.t74 sky130_fd_pr__nfet_01v8 ad=0.1092 pd=1.36 as=0.1449 ps=1.11 w=0.42 l=0.15
X45 a_n2560_n1661# x2.x5.A1 a_n2418_n1813# GND.t9 sky130_fd_pr__nfet_01v8 ad=0.09975 pd=0.895 as=0.0693 ps=0.75 w=0.42 l=0.15
X46 a_n2193_n3193# x5.A1 GND.t26 GND.t25 sky130_fd_pr__nfet_01v8 ad=0.1092 pd=1.36 as=0.1449 ps=1.11 w=0.42 l=0.15
X47 a_n535_n2525# P2.t4 VDD.t69 VDD.t68 sky130_fd_pr__pfet_01v8_hvt ad=0.1176 pd=1.4 as=0.0693 ps=0.75 w=0.42 l=0.15
X48 x3.B a_n1800_n2249# GND.t21 GND.t20 sky130_fd_pr__nfet_01v8 ad=0.169 pd=1.82 as=0.10025 ps=0.985 w=0.65 l=0.15
X49 a_n1800_n2249# x1.x3.B GND.t60 GND.t59 sky130_fd_pr__nfet_01v8 ad=0.0567 pd=0.69 as=0.1092 ps=1.36 w=0.42 l=0.15
X50 x2.x5.A1 A[5].t0 GND.t79 GND.t78 sky130_fd_pr__nfet_01v8 ad=0.169 pd=1.82 as=0.169 ps=1.82 w=0.65 l=0.15
X51 GND.t3 x2.x4.A a_n1738_n895# GND.t2 sky130_fd_pr__nfet_01v8 ad=0.10025 pd=0.985 as=0.0567 ps=0.69 w=0.42 l=0.15
X52 x3.B a_n1800_n2249# VDD.t21 VDD.t20 sky130_fd_pr__pfet_01v8_hvt ad=0.34 pd=2.68 as=0.14575 ps=1.335 w=1 l=0.15
X53 GND.t67 A[7].t1 a_n2566_n895# GND.t66 sky130_fd_pr__nfet_01v8 ad=0.10025 pd=0.985 as=0.0567 ps=0.69 w=0.42 l=0.15
X54 a_n2628_n2249# A[2].t0 GND.t87 GND.t86 sky130_fd_pr__nfet_01v8 ad=0.0567 pd=0.69 as=0.1092 ps=1.36 w=0.42 l=0.15
X55 a_n383_n1839# P2.t8 VDD.t73 VDD.t72 sky130_fd_pr__pfet_01v8_hvt ad=0.1176 pd=1.4 as=0.0693 ps=0.75 w=0.42 l=0.15
X56 P2.t1 x4.A GND.t34 GND.t33 sky130_fd_pr__nfet_01v8 ad=0.169 pd=1.82 as=0.169 ps=1.82 w=0.65 l=0.15
X57 a_n383_n1839# P2.t6 GND.t77 GND.t76 sky130_fd_pr__nfet_01v8 ad=0.1092 pd=1.36 as=0.1449 ps=1.11 w=0.42 l=0.15
X58 VDD.t30 a_n535_n2525# a_n505_n2172# VDD.t29 sky130_fd_pr__pfet_01v8_hvt ad=0.0693 pd=0.75 as=0.0441 ps=0.63 w=0.42 l=0.15
X59 GND.t30 a_n535_n2525# a_n601_n2499# GND.t29 sky130_fd_pr__nfet_01v8 ad=0.1449 pd=1.11 as=0.0693 ps=0.75 w=0.42 l=0.15
X60 VDD.t8 a_n2131_n1839# a_n2101_n1486# VDD.t7 sky130_fd_pr__pfet_01v8_hvt ad=0.0693 pd=0.75 as=0.0441 ps=0.63 w=0.42 l=0.15
X61 VDD.t5 x2.x4.A a_n1656_n895# VDD.t4 sky130_fd_pr__pfet_01v8_hvt ad=0.14575 pd=1.335 as=0.0441 ps=0.63 w=0.42 l=0.15
X62 V.t0 a_n910_n895# VDD.t36 VDD.t35 sky130_fd_pr__pfet_01v8_hvt ad=0.34 pd=2.68 as=0.14575 ps=1.335 w=1 l=0.15
X63 VDD.t63 A[7].t3 a_n2484_n895# VDD.t62 sky130_fd_pr__pfet_01v8_hvt ad=0.14575 pd=1.335 as=0.0441 ps=0.63 w=0.42 l=0.15
X64 a_n505_n2172# x5.A1 a_n964_n2347# VDD.t22 sky130_fd_pr__pfet_01v8_hvt ad=0.0441 pd=0.63 as=0.1932 ps=1.34 w=0.42 l=0.15
X65 a_n2259_n3167# x1.x5.A0 a_n2622_n3015# GND.t6 sky130_fd_pr__nfet_01v8 ad=0.0693 pd=0.75 as=0.09975 ps=0.895 w=0.42 l=0.15
X66 a_n964_n2347# x5.A1 a_n822_n2499# GND.t22 sky130_fd_pr__nfet_01v8 ad=0.09975 pd=0.895 as=0.0693 ps=0.75 w=0.42 l=0.15
X67 a_n2622_n3015# x1.x5.A1 a_n2480_n3167# GND.t39 sky130_fd_pr__nfet_01v8 ad=0.09975 pd=0.895 as=0.0693 ps=0.75 w=0.42 l=0.15
X68 VDD.t51 a_n383_n1839# a_n353_n1486# VDD.t50 sky130_fd_pr__pfet_01v8_hvt ad=0.0693 pd=0.75 as=0.0441 ps=0.63 w=0.42 l=0.15
X69 a_n2622_n3015# x1.x5.A0 a_n2480_n2840# VDD.t6 sky130_fd_pr__pfet_01v8_hvt ad=0.1932 pd=1.34 as=0.07665 ps=0.785 w=0.42 l=0.15
X70 GND.t91 A[3].t1 a_n2628_n2249# GND.t90 sky130_fd_pr__nfet_01v8 ad=0.10025 pd=0.985 as=0.0567 ps=0.69 w=0.42 l=0.15
X71 a_n2480_n2840# x5.A1 VDD.t26 VDD.t25 sky130_fd_pr__pfet_01v8_hvt ad=0.07665 pd=0.785 as=0.15835 ps=1.395 w=0.42 l=0.15
X72 VDD.t86 A[3].t3 a_n2546_n2249# VDD.t85 sky130_fd_pr__pfet_01v8_hvt ad=0.14575 pd=1.335 as=0.0441 ps=0.63 w=0.42 l=0.15
X73 x4.A a_n1738_n895# GND.t41 GND.t40 sky130_fd_pr__nfet_01v8 ad=0.169 pd=1.82 as=0.10025 ps=0.985 w=0.65 l=0.15
X74 a_n601_n2499# x5.A0 a_n964_n2347# GND.t46 sky130_fd_pr__nfet_01v8 ad=0.0693 pd=0.75 as=0.09975 ps=0.895 w=0.42 l=0.15
X75 GND.t15 a_n964_n2347# P1.t1 GND.t14 sky130_fd_pr__nfet_01v8 ad=0.11285 pd=1.045 as=0.169 ps=1.82 w=0.65 l=0.15
X76 VDD.t15 a_n964_n2347# P1.t0 VDD.t14 sky130_fd_pr__pfet_01v8_hvt ad=0.15835 pd=1.395 as=0.26 ps=2.52 w=1 l=0.15
X77 x2.x4.A a_n2566_n895# GND.t38 GND.t37 sky130_fd_pr__nfet_01v8 ad=0.169 pd=1.82 as=0.10025 ps=0.985 w=0.65 l=0.15
X78 a_n812_n1661# x6.A0 a_n670_n1486# VDD.t10 sky130_fd_pr__pfet_01v8_hvt ad=0.1932 pd=1.34 as=0.07665 ps=0.785 w=0.42 l=0.15
X79 a_n2566_n895# A[6].t0 GND.t63 GND.t62 sky130_fd_pr__nfet_01v8 ad=0.0567 pd=0.69 as=0.1092 ps=1.36 w=0.42 l=0.15
X80 a_n822_n2499# P2.t3 GND.t73 GND.t72 sky130_fd_pr__nfet_01v8 ad=0.0693 pd=0.75 as=0.11285 ps=1.045 w=0.42 l=0.15
X81 x1.x3.B a_n1802_n2917# VDD.t28 VDD.t27 sky130_fd_pr__pfet_01v8_hvt ad=0.34 pd=2.68 as=0.14575 ps=1.335 w=1 l=0.15
X82 a_n449_n1813# x6.A0 a_n812_n1661# GND.t10 sky130_fd_pr__nfet_01v8 ad=0.0693 pd=0.75 as=0.09975 ps=0.895 w=0.42 l=0.15
X83 a_n670_n1486# P2.t9 VDD.t71 VDD.t70 sky130_fd_pr__pfet_01v8_hvt ad=0.07665 pd=0.785 as=0.15835 ps=1.395 w=0.42 l=0.15
X84 a_n822_n2172# P2.t5 VDD.t67 VDD.t66 sky130_fd_pr__pfet_01v8_hvt ad=0.07665 pd=0.785 as=0.15835 ps=1.395 w=0.42 l=0.15
X85 a_n812_n1661# x6.A1 a_n670_n1813# GND.t13 sky130_fd_pr__nfet_01v8 ad=0.09975 pd=0.895 as=0.0693 ps=0.75 w=0.42 l=0.15
X86 x2.x5.A1 A[5].t2 VDD.t77 VDD.t76 sky130_fd_pr__pfet_01v8_hvt ad=0.26 pd=2.52 as=0.26 ps=2.52 w=1 l=0.15
X87 a_n2484_n895# A[6].t1 a_n2566_n895# VDD.t59 sky130_fd_pr__pfet_01v8_hvt ad=0.0441 pd=0.63 as=0.1092 ps=1.36 w=0.42 l=0.15
X88 a_n2560_n1661# x2.x5.A0 a_n2418_n1486# VDD.t58 sky130_fd_pr__pfet_01v8_hvt ad=0.1932 pd=1.34 as=0.07665 ps=0.785 w=0.42 l=0.15
X89 x5.A0 x2.x4.A VDD.t3 VDD.t2 sky130_fd_pr__pfet_01v8_hvt ad=0.26 pd=2.52 as=0.26 ps=2.52 w=1 l=0.15
X90 a_n670_n1813# P2.t7 GND.t71 GND.t70 sky130_fd_pr__nfet_01v8 ad=0.0693 pd=0.75 as=0.11285 ps=1.045 w=0.42 l=0.15
X91 x2.x5.A0 A[7].t2 VDD.t65 VDD.t64 sky130_fd_pr__pfet_01v8_hvt ad=0.26 pd=2.52 as=0.26 ps=2.52 w=1 l=0.15
X92 x1.x3.B a_n1802_n2917# GND.t28 GND.t27 sky130_fd_pr__nfet_01v8 ad=0.169 pd=1.82 as=0.10025 ps=0.985 w=0.65 l=0.15
X93 a_n1802_n2917# A[0].t0 GND.t95 GND.t94 sky130_fd_pr__nfet_01v8 ad=0.0567 pd=0.69 as=0.1092 ps=1.36 w=0.42 l=0.15
X94 a_n2197_n1813# x2.x5.A0 a_n2560_n1661# GND.t61 sky130_fd_pr__nfet_01v8 ad=0.0693 pd=0.75 as=0.09975 ps=0.895 w=0.42 l=0.15
X95 GND.t50 a_n2560_n1661# x6.A0 GND.t49 sky130_fd_pr__nfet_01v8 ad=0.11285 pd=1.045 as=0.169 ps=1.82 w=0.65 l=0.15
X96 a_n2418_n1486# x5.A0 VDD.t43 VDD.t42 sky130_fd_pr__pfet_01v8_hvt ad=0.07665 pd=0.785 as=0.15835 ps=1.395 w=0.42 l=0.15
X97 VDD.t81 A[1].t3 a_n1720_n2917# VDD.t80 sky130_fd_pr__pfet_01v8_hvt ad=0.14575 pd=1.335 as=0.0441 ps=0.63 w=0.42 l=0.15
X98 a_n2418_n1813# x5.A0 GND.t45 GND.t44 sky130_fd_pr__nfet_01v8 ad=0.0693 pd=0.75 as=0.11285 ps=1.045 w=0.42 l=0.15
X99 x5.A1 x1.x4.A GND.t19 GND.t18 sky130_fd_pr__nfet_01v8 ad=0.169 pd=1.82 as=0.169 ps=1.82 w=0.65 l=0.15
X100 GND.t83 A[1].t1 a_n1802_n2917# GND.t82 sky130_fd_pr__nfet_01v8 ad=0.10025 pd=0.985 as=0.0567 ps=0.69 w=0.42 l=0.15
X101 a_n1720_n2917# A[0].t1 a_n1802_n2917# VDD.t88 sky130_fd_pr__pfet_01v8_hvt ad=0.0441 pd=0.63 as=0.1092 ps=1.36 w=0.42 l=0.15
X102 x5.A1 x1.x4.A VDD.t17 VDD.t16 sky130_fd_pr__pfet_01v8_hvt ad=0.26 pd=2.52 as=0.26 ps=2.52 w=1 l=0.15
X103 a_n1740_n1563# A[4].t0 GND.t93 GND.t92 sky130_fd_pr__nfet_01v8 ad=0.0567 pd=0.69 as=0.1092 ps=1.36 w=0.42 l=0.15
R0 A[0].n0 A[0].t0 192.639
R1 A[0].n1 A[0].n0 155.887
R2 A[0].n0 A[0].t1 134.799
R3 A[0].n2 A[0].n1 9.43628
R4 A[0].n1 A[0] 2.28621
R5 A[0] A[0].n2 0.0571406
R6 A[0].n2 A[0] 0.0306724
R7 A[1].n0 A[1].t2 230.576
R8 A[1].n2 A[1].t1 206.19
R9 A[1].n0 A[1].t0 158.275
R10 A[1].n1 A[1].n0 154.133
R11 A[1].n3 A[1].n2 152
R12 A[1].n2 A[1].t3 148.35
R13 A[1].n4 A[1].n3 10.7882
R14 A[1].n4 A[1].n1 9.9376
R15 A[1] A[1].n5 4.61184
R16 A[1].n1 A[1] 4.53383
R17 A[1].n5 A[1].n4 0.781064
R18 A[1].n3 A[1] 0.686214
R19 A[1].n5 A[1] 0.0987143
R20 A[1].n5 A[1] 0.0686818
R21 P1.n3 P1 593.216
R22 P1.n3 P1.n2 585
R23 P1.n4 P1.n3 585
R24 P1.n1 P1.t1 209.923
R25 P1.n4 P1.n1 74.3207
R26 P1.n3 P1.t0 26.5955
R27 P1.n0 P1 13.2416
R28 P1 P1.n0 5.92289
R29 P1.n2 P1 4.77662
R30 P1 P1.n4 4.77662
R31 P1.n1 P1 2.5103
R32 P1.n2 P1.n0 2.29304
R33 A[2].n0 A[2].t0 192.639
R34 A[2].n1 A[2].n0 155.887
R35 A[2].n0 A[2].t1 134.799
R36 A[2] A[2].n1 9.46645
R37 A[2].n1 A[2] 2.28621
R38 A[3].n0 A[3].t2 230.576
R39 A[3].n2 A[3].t1 206.19
R40 A[3].n0 A[3].t0 158.275
R41 A[3].n1 A[3].n0 154.133
R42 A[3].n3 A[3].n2 152
R43 A[3].n2 A[3].t3 148.35
R44 A[3].n4 A[3].n3 10.7882
R45 A[3].n4 A[3].n1 9.9376
R46 A[3].n1 A[3] 4.53383
R47 A[3] A[3].n4 0.849246
R48 A[3].n3 A[3] 0.686214
R49 P0.n3 P0 593.216
R50 P0.n3 P0.n2 585
R51 P0.n4 P0.n3 585
R52 P0.n1 P0.t1 209.923
R53 P0.n4 P0.n1 74.3207
R54 P0.n3 P0.t0 26.5955
R55 P0.n0 P0 12.817
R56 P0 P0.n0 7.83334
R57 P0.n2 P0 4.77662
R58 P0 P0.n4 4.77662
R59 P0.n1 P0 2.5103
R60 P0.n2 P0.n0 0.38259
R61 A[4].n0 A[4].t0 192.639
R62 A[4].n1 A[4].n0 155.887
R63 A[4].n0 A[4].t1 134.799
R64 A[4].n2 A[4].n1 9.43628
R65 A[4].n1 A[4] 2.28621
R66 A[4] A[4].n2 0.0571406
R67 A[4].n2 A[4] 0.0306724
R68 A[5].n0 A[5].t2 230.576
R69 A[5].n2 A[5].t1 206.19
R70 A[5].n0 A[5].t0 158.275
R71 A[5].n1 A[5].n0 154.133
R72 A[5].n3 A[5].n2 152
R73 A[5].n2 A[5].t3 148.35
R74 A[5].n4 A[5].n3 10.7882
R75 A[5].n4 A[5].n1 9.9376
R76 A[5] A[5].n5 4.61184
R77 A[5].n1 A[5] 4.53383
R78 A[5].n5 A[5].n4 0.781064
R79 A[5].n3 A[5] 0.686214
R80 A[5].n5 A[5] 0.0987143
R81 A[5].n5 A[5] 0.0686818
R82 P2 P2.n5 428.005
R83 P2 P2.n9 428.005
R84 P2.n4 P2.t6 329.902
R85 P2.n0 P2.t2 329.902
R86 P2.n5 P2.t9 272.062
R87 P2.n9 P2.t5 272.062
R88 P2.n2 P2.t0 221.666
R89 P2.n5 P2.t7 206.19
R90 P2.n9 P2.t3 206.19
R91 P2 P2.t1 152.889
R92 P2 P2.n4 152.674
R93 P2 P2.n0 152.674
R94 P2.n4 P2.t8 148.35
R95 P2.n0 P2.t4 148.35
R96 P2.n6 P2 24.9268
R97 P2.n8 P2 24.9268
R98 P2.n8 P2.n7 17.5606
R99 P2.n3 P2.n2 17.4891
R100 P2.n2 P2.n1 13.8961
R101 P2.n7 P2.n6 13.8005
R102 P2.n6 P2 6.06366
R103 P2 P2.n8 6.06366
R104 P2.n7 P2.n3 2.57203
R105 P2.n1 P2 2.22659
R106 P2.n1 P2 1.55202
R107 P2.n3 P2 0.569392
R108 V.n0 V.t0 340.584
R109 V V.n1 156.806
R110 V.n1 V.t1 132.655
R111 V.n1 V 11.1619
R112 V V.n0 2.4386
R113 V.n0 V 1.43601
R114 A[6].n0 A[6].t0 192.639
R115 A[6].n1 A[6].n0 155.887
R116 A[6].n0 A[6].t1 134.799
R117 A[6] A[6].n1 9.46645
R118 A[6].n1 A[6] 2.28621
R119 A[7].n0 A[7].t2 230.576
R120 A[7].n2 A[7].t1 206.19
R121 A[7].n0 A[7].t0 158.275
R122 A[7].n1 A[7].n0 154.133
R123 A[7].n3 A[7].n2 152
R124 A[7].n2 A[7].t3 148.35
R125 A[7].n4 A[7].n3 10.7882
R126 A[7].n4 A[7].n1 9.9376
R127 A[7].n1 A[7] 4.53383
R128 A[7] A[7].n4 0.849246
R129 A[7].n3 A[7] 0.686214
R130 VDD.n204 VDD.t78 766.545
R131 VDD.n19 VDD.t33 766.545
R132 VDD.n148 VDD.t68 763.587
R133 VDD.n81 VDD.t72 763.587
R134 VDD.t39 VDD.t6 633.333
R135 VDD.t22 VDD.t46 633.333
R136 VDD.t13 VDD.t10 633.333
R137 VDD.t9 VDD.t58 633.333
R138 VDD.n220 VDD.n219 629.801
R139 VDD.n144 VDD.n143 629.801
R140 VDD.n66 VDD.n65 629.801
R141 VDD.n79 VDD.n78 629.801
R142 VDD VDD.n73 627.414
R143 VDD.n147 VDD.t16 553.428
R144 VDD.n146 VDD.t83 553.428
R145 VDD.n73 VDD.t76 553.428
R146 VDD.n18 VDD.t2 553.428
R147 VDD.n17 VDD.t64 553.428
R148 VDD VDD.t27 547.509
R149 VDD VDD.t20 547.509
R150 VDD VDD.t55 547.509
R151 VDD VDD.t53 547.509
R152 VDD VDD.t35 547.509
R153 VDD VDD.t40 547.509
R154 VDD VDD.t37 547.509
R155 VDD VDD.t23 500.156
R156 VDD VDD.t44 500.156
R157 VDD VDD.n147 355.14
R158 VDD.t25 VDD.t0 322.587
R159 VDD.t66 VDD.t14 322.587
R160 VDD.t70 VDD.t11 322.587
R161 VDD.t42 VDD.t48 322.587
R162 VDD.n213 VDD.n201 315.303
R163 VDD.n188 VDD.n129 315.303
R164 VDD.n174 VDD.n135 315.303
R165 VDD.n106 VDD.n70 315.303
R166 VDD.n43 VDD.n8 315.303
R167 VDD.n29 VDD.n14 315.303
R168 VDD.n57 VDD.n2 315.301
R169 VDD.t78 VDD 313.707
R170 VDD.t88 VDD 313.707
R171 VDD.t16 VDD 313.707
R172 VDD.t57 VDD 313.707
R173 VDD.t83 VDD 313.707
R174 VDD.t82 VDD 313.707
R175 VDD.t76 VDD 313.707
R176 VDD.t87 VDD 313.707
R177 VDD.t33 VDD 313.707
R178 VDD.t47 VDD 313.707
R179 VDD.t2 VDD 313.707
R180 VDD.t52 VDD 313.707
R181 VDD.t64 VDD 313.707
R182 VDD.t59 VDD 313.707
R183 VDD.t6 VDD.t25 304.829
R184 VDD.t46 VDD.t66 304.829
R185 VDD.t10 VDD.t70 304.829
R186 VDD.t58 VDD.t42 304.829
R187 VDD.t27 VDD.t80 287.072
R188 VDD.t20 VDD.t18 287.072
R189 VDD.t55 VDD.t85 287.072
R190 VDD.t53 VDD.t74 287.072
R191 VDD.t35 VDD.t31 287.072
R192 VDD.t40 VDD.t4 287.072
R193 VDD.t37 VDD.t62 287.072
R194 VDD.t23 VDD.t60 284.113
R195 VDD.t68 VDD.t29 284.113
R196 VDD.t72 VDD.t50 284.113
R197 VDD.t44 VDD.t7 284.113
R198 VDD.n206 VDD.t79 255.905
R199 VDD.n182 VDD.t84 255.905
R200 VDD.n168 VDD.t17 255.905
R201 VDD.n99 VDD.t77 255.905
R202 VDD.n51 VDD.t65 255.905
R203 VDD.n37 VDD.t3 255.905
R204 VDD.n23 VDD.t34 255.905
R205 VDD.n232 VDD.n194 235.248
R206 VDD.n161 VDD.n140 235.248
R207 VDD.n123 VDD.n62 235.248
R208 VDD.n94 VDD.n75 235.248
R209 VDD VDD.n146 221.964
R210 VDD VDD.n18 221.964
R211 VDD VDD.n17 221.964
R212 VDD.n146 VDD.n132 213.119
R213 VDD.n147 VDD.n138 213.119
R214 VDD.n97 VDD.n73 213.119
R215 VDD.n17 VDD.n5 213.119
R216 VDD.n18 VDD.n11 213.119
R217 VDD.t80 VDD.t88 213.084
R218 VDD.t60 VDD.t39 213.084
R219 VDD.t29 VDD.t22 213.084
R220 VDD.t18 VDD.t57 213.084
R221 VDD.t85 VDD.t82 213.084
R222 VDD.t50 VDD.t13 213.084
R223 VDD.t74 VDD.t87 213.084
R224 VDD.t7 VDD.t9 213.084
R225 VDD.t31 VDD.t47 213.084
R226 VDD.t4 VDD.t52 213.084
R227 VDD.t62 VDD.t59 213.084
R228 VDD.n194 VDD.t26 123.507
R229 VDD.n140 VDD.t67 123.507
R230 VDD.n62 VDD.t43 123.507
R231 VDD.n75 VDD.t71 123.507
R232 VDD.n201 VDD.t81 96.1553
R233 VDD.n129 VDD.t86 96.1553
R234 VDD.n135 VDD.t19 96.1553
R235 VDD.n70 VDD.t75 96.1553
R236 VDD.n2 VDD.t63 96.1553
R237 VDD.n8 VDD.t5 96.1553
R238 VDD.n14 VDD.t32 96.1553
R239 VDD.n219 VDD.t61 86.7743
R240 VDD.n143 VDD.t30 86.7743
R241 VDD.n65 VDD.t8 86.7743
R242 VDD.n78 VDD.t51 86.7743
R243 VDD.n219 VDD.t24 68.0124
R244 VDD.n143 VDD.t69 68.0124
R245 VDD.n65 VDD.t45 68.0124
R246 VDD.n78 VDD.t73 68.0124
R247 VDD.t0 VDD 59.1905
R248 VDD.t14 VDD 59.1905
R249 VDD.t11 VDD 59.1905
R250 VDD.t48 VDD 59.1905
R251 VDD.n190 VDD.n189 43.9358
R252 VDD.n59 VDD.n58 43.9358
R253 VDD.n233 VDD.n232 43.1829
R254 VDD.n124 VDD.n123 43.1829
R255 VDD.n95 VDD.n94 43.1829
R256 VDD.n217 VDD.n199 34.6358
R257 VDD.n218 VDD.n217 34.6358
R258 VDD.n221 VDD.n218 34.6358
R259 VDD.n225 VDD.n197 34.6358
R260 VDD.n226 VDD.n225 34.6358
R261 VDD.n227 VDD.n226 34.6358
R262 VDD.n227 VDD.n195 34.6358
R263 VDD.n231 VDD.n195 34.6358
R264 VDD.n211 VDD.n202 34.6358
R265 VDD.n212 VDD.n211 34.6358
R266 VDD.n207 VDD.n205 34.6358
R267 VDD.n183 VDD.n130 34.6358
R268 VDD.n187 VDD.n130 34.6358
R269 VDD.n181 VDD.n180 34.6358
R270 VDD.n176 VDD.n175 34.6358
R271 VDD.n169 VDD.n136 34.6358
R272 VDD.n173 VDD.n136 34.6358
R273 VDD.n167 VDD.n166 34.6358
R274 VDD.n150 VDD.n149 34.6358
R275 VDD.n154 VDD.n153 34.6358
R276 VDD.n155 VDD.n154 34.6358
R277 VDD.n155 VDD.n141 34.6358
R278 VDD.n159 VDD.n141 34.6358
R279 VDD.n160 VDD.n159 34.6358
R280 VDD.n110 VDD.n68 34.6358
R281 VDD.n111 VDD.n110 34.6358
R282 VDD.n112 VDD.n111 34.6358
R283 VDD.n116 VDD.n115 34.6358
R284 VDD.n117 VDD.n116 34.6358
R285 VDD.n117 VDD.n63 34.6358
R286 VDD.n121 VDD.n63 34.6358
R287 VDD.n122 VDD.n121 34.6358
R288 VDD.n104 VDD.n71 34.6358
R289 VDD.n105 VDD.n104 34.6358
R290 VDD.n100 VDD.n98 34.6358
R291 VDD.n83 VDD.n82 34.6358
R292 VDD.n87 VDD.n86 34.6358
R293 VDD.n88 VDD.n87 34.6358
R294 VDD.n88 VDD.n76 34.6358
R295 VDD.n92 VDD.n76 34.6358
R296 VDD.n93 VDD.n92 34.6358
R297 VDD.n52 VDD.n3 34.6358
R298 VDD.n56 VDD.n3 34.6358
R299 VDD.n50 VDD.n49 34.6358
R300 VDD.n45 VDD.n44 34.6358
R301 VDD.n38 VDD.n9 34.6358
R302 VDD.n42 VDD.n9 34.6358
R303 VDD.n36 VDD.n35 34.6358
R304 VDD.n31 VDD.n30 34.6358
R305 VDD.n24 VDD.n15 34.6358
R306 VDD.n28 VDD.n15 34.6358
R307 VDD.n22 VDD.n21 34.6358
R308 VDD.n213 VDD.n199 34.2593
R309 VDD.n189 VDD.n188 34.2593
R310 VDD.n175 VDD.n174 34.2593
R311 VDD.n106 VDD.n68 34.2593
R312 VDD.n58 VDD.n57 34.2593
R313 VDD.n44 VDD.n43 34.2593
R314 VDD.n30 VDD.n29 34.2593
R315 VDD.n162 VDD.n161 33.8829
R316 VDD.n194 VDD.t1 28.752
R317 VDD.n140 VDD.t15 28.752
R318 VDD.n62 VDD.t49 28.752
R319 VDD.n75 VDD.t12 28.752
R320 VDD.n201 VDD.t28 25.6105
R321 VDD.n129 VDD.t56 25.6105
R322 VDD.n135 VDD.t21 25.6105
R323 VDD.n70 VDD.t54 25.6105
R324 VDD.n2 VDD.t38 25.6105
R325 VDD.n8 VDD.t41 25.6105
R326 VDD.n14 VDD.t36 25.6105
R327 VDD.n205 VDD.n204 23.7181
R328 VDD.n180 VDD.n132 23.7181
R329 VDD.n176 VDD.n132 23.7181
R330 VDD.n166 VDD.n138 23.7181
R331 VDD.n149 VDD.n148 23.7181
R332 VDD.n162 VDD.n138 23.7181
R333 VDD.n98 VDD.n97 23.7181
R334 VDD.n82 VDD.n81 23.7181
R335 VDD.n49 VDD.n5 23.7181
R336 VDD.n45 VDD.n5 23.7181
R337 VDD.n35 VDD.n11 23.7181
R338 VDD.n31 VDD.n11 23.7181
R339 VDD.n21 VDD.n19 23.7181
R340 VDD.n221 VDD.n220 17.3181
R341 VDD.n220 VDD.n197 17.3181
R342 VDD.n150 VDD.n144 17.3181
R343 VDD.n153 VDD.n144 17.3181
R344 VDD.n112 VDD.n66 17.3181
R345 VDD.n115 VDD.n66 17.3181
R346 VDD.n83 VDD.n79 17.3181
R347 VDD.n86 VDD.n79 17.3181
R348 VDD.n207 VDD.n206 10.5417
R349 VDD.n182 VDD.n181 10.5417
R350 VDD.n168 VDD.n167 10.5417
R351 VDD.n100 VDD.n99 10.5417
R352 VDD.n51 VDD.n50 10.5417
R353 VDD.n37 VDD.n36 10.5417
R354 VDD.n23 VDD.n22 10.5417
R355 VDD.n213 VDD.n212 10.1652
R356 VDD.n188 VDD.n187 10.1652
R357 VDD.n174 VDD.n173 10.1652
R358 VDD.n106 VDD.n105 10.1652
R359 VDD.n57 VDD.n56 10.1652
R360 VDD.n43 VDD.n42 10.1652
R361 VDD.n29 VDD.n28 10.1652
R362 VDD.n148 VDD 9.33175
R363 VDD.n81 VDD 9.33175
R364 VDD VDD.n19 9.33175
R365 VDD.n204 VDD 9.33175
R366 VDD.n149 VDD.n145 9.3005
R367 VDD.n151 VDD.n150 9.3005
R368 VDD.n153 VDD.n152 9.3005
R369 VDD.n154 VDD.n142 9.3005
R370 VDD.n156 VDD.n155 9.3005
R371 VDD.n157 VDD.n141 9.3005
R372 VDD.n159 VDD.n158 9.3005
R373 VDD.n160 VDD.n139 9.3005
R374 VDD.n163 VDD.n162 9.3005
R375 VDD.n164 VDD.n138 9.3005
R376 VDD.n166 VDD.n165 9.3005
R377 VDD.n167 VDD.n137 9.3005
R378 VDD.n170 VDD.n169 9.3005
R379 VDD.n171 VDD.n136 9.3005
R380 VDD.n173 VDD.n172 9.3005
R381 VDD.n174 VDD.n134 9.3005
R382 VDD.n175 VDD.n133 9.3005
R383 VDD.n177 VDD.n176 9.3005
R384 VDD.n178 VDD.n132 9.3005
R385 VDD.n180 VDD.n179 9.3005
R386 VDD.n181 VDD.n131 9.3005
R387 VDD.n184 VDD.n183 9.3005
R388 VDD.n185 VDD.n130 9.3005
R389 VDD.n187 VDD.n186 9.3005
R390 VDD.n188 VDD.n128 9.3005
R391 VDD.n189 VDD.n127 9.3005
R392 VDD.n82 VDD.n80 9.3005
R393 VDD.n84 VDD.n83 9.3005
R394 VDD.n86 VDD.n85 9.3005
R395 VDD.n87 VDD.n77 9.3005
R396 VDD.n89 VDD.n88 9.3005
R397 VDD.n90 VDD.n76 9.3005
R398 VDD.n92 VDD.n91 9.3005
R399 VDD.n93 VDD.n74 9.3005
R400 VDD.n97 VDD.n96 9.3005
R401 VDD.n98 VDD.n72 9.3005
R402 VDD.n101 VDD.n100 9.3005
R403 VDD.n102 VDD.n71 9.3005
R404 VDD.n104 VDD.n103 9.3005
R405 VDD.n105 VDD.n69 9.3005
R406 VDD.n107 VDD.n106 9.3005
R407 VDD.n108 VDD.n68 9.3005
R408 VDD.n110 VDD.n109 9.3005
R409 VDD.n111 VDD.n67 9.3005
R410 VDD.n113 VDD.n112 9.3005
R411 VDD.n115 VDD.n114 9.3005
R412 VDD.n116 VDD.n64 9.3005
R413 VDD.n118 VDD.n117 9.3005
R414 VDD.n119 VDD.n63 9.3005
R415 VDD.n121 VDD.n120 9.3005
R416 VDD.n122 VDD.n61 9.3005
R417 VDD.n21 VDD.n20 9.3005
R418 VDD.n22 VDD.n16 9.3005
R419 VDD.n25 VDD.n24 9.3005
R420 VDD.n26 VDD.n15 9.3005
R421 VDD.n28 VDD.n27 9.3005
R422 VDD.n29 VDD.n13 9.3005
R423 VDD.n30 VDD.n12 9.3005
R424 VDD.n32 VDD.n31 9.3005
R425 VDD.n33 VDD.n11 9.3005
R426 VDD.n35 VDD.n34 9.3005
R427 VDD.n36 VDD.n10 9.3005
R428 VDD.n39 VDD.n38 9.3005
R429 VDD.n40 VDD.n9 9.3005
R430 VDD.n42 VDD.n41 9.3005
R431 VDD.n43 VDD.n7 9.3005
R432 VDD.n44 VDD.n6 9.3005
R433 VDD.n46 VDD.n45 9.3005
R434 VDD.n47 VDD.n5 9.3005
R435 VDD.n49 VDD.n48 9.3005
R436 VDD.n50 VDD.n4 9.3005
R437 VDD.n53 VDD.n52 9.3005
R438 VDD.n54 VDD.n3 9.3005
R439 VDD.n56 VDD.n55 9.3005
R440 VDD.n57 VDD.n1 9.3005
R441 VDD.n58 VDD.n0 9.3005
R442 VDD.n205 VDD.n203 9.3005
R443 VDD.n208 VDD.n207 9.3005
R444 VDD.n209 VDD.n202 9.3005
R445 VDD.n211 VDD.n210 9.3005
R446 VDD.n212 VDD.n200 9.3005
R447 VDD.n214 VDD.n213 9.3005
R448 VDD.n215 VDD.n199 9.3005
R449 VDD.n217 VDD.n216 9.3005
R450 VDD.n218 VDD.n198 9.3005
R451 VDD.n222 VDD.n221 9.3005
R452 VDD.n223 VDD.n197 9.3005
R453 VDD.n225 VDD.n224 9.3005
R454 VDD.n226 VDD.n196 9.3005
R455 VDD.n228 VDD.n227 9.3005
R456 VDD.n229 VDD.n195 9.3005
R457 VDD.n231 VDD.n230 9.3005
R458 VDD.n126 VDD.n60 8.36084
R459 VDD.n193 VDD.n192 8.3517
R460 VDD.n206 VDD.n202 8.28285
R461 VDD.n183 VDD.n182 8.28285
R462 VDD.n169 VDD.n168 8.28285
R463 VDD.n99 VDD.n71 8.28285
R464 VDD.n52 VDD.n51 8.28285
R465 VDD.n38 VDD.n37 8.28285
R466 VDD.n24 VDD.n23 8.28285
R467 VDD.n192 VDD.n191 7.91496
R468 VDD.n126 VDD.n125 7.9105
R469 VDD.n232 VDD.n231 0.753441
R470 VDD.n161 VDD.n160 0.753441
R471 VDD.n123 VDD.n122 0.753441
R472 VDD.n94 VDD.n93 0.753441
R473 VDD.n192 VDD.n126 0.461642
R474 VDD.n96 VDD 0.180188
R475 VDD.n151 VDD.n145 0.120292
R476 VDD.n152 VDD.n151 0.120292
R477 VDD.n152 VDD.n142 0.120292
R478 VDD.n156 VDD.n142 0.120292
R479 VDD.n157 VDD.n156 0.120292
R480 VDD.n158 VDD.n157 0.120292
R481 VDD.n158 VDD.n139 0.120292
R482 VDD.n163 VDD.n139 0.120292
R483 VDD.n165 VDD.n137 0.120292
R484 VDD.n170 VDD.n137 0.120292
R485 VDD.n172 VDD.n171 0.120292
R486 VDD.n172 VDD.n134 0.120292
R487 VDD.n134 VDD.n133 0.120292
R488 VDD.n177 VDD.n133 0.120292
R489 VDD.n179 VDD.n131 0.120292
R490 VDD.n184 VDD.n131 0.120292
R491 VDD.n186 VDD.n185 0.120292
R492 VDD.n186 VDD.n128 0.120292
R493 VDD.n128 VDD.n127 0.120292
R494 VDD.n84 VDD.n80 0.120292
R495 VDD.n85 VDD.n84 0.120292
R496 VDD.n85 VDD.n77 0.120292
R497 VDD.n89 VDD.n77 0.120292
R498 VDD.n90 VDD.n89 0.120292
R499 VDD.n91 VDD.n90 0.120292
R500 VDD.n91 VDD.n74 0.120292
R501 VDD.n95 VDD.n74 0.120292
R502 VDD.n101 VDD.n72 0.120292
R503 VDD.n102 VDD.n101 0.120292
R504 VDD.n103 VDD.n69 0.120292
R505 VDD.n107 VDD.n69 0.120292
R506 VDD.n108 VDD.n107 0.120292
R507 VDD.n109 VDD.n108 0.120292
R508 VDD.n113 VDD.n67 0.120292
R509 VDD.n114 VDD.n113 0.120292
R510 VDD.n114 VDD.n64 0.120292
R511 VDD.n118 VDD.n64 0.120292
R512 VDD.n119 VDD.n118 0.120292
R513 VDD.n120 VDD.n119 0.120292
R514 VDD.n120 VDD.n61 0.120292
R515 VDD.n20 VDD.n16 0.120292
R516 VDD.n25 VDD.n16 0.120292
R517 VDD.n27 VDD.n26 0.120292
R518 VDD.n27 VDD.n13 0.120292
R519 VDD.n13 VDD.n12 0.120292
R520 VDD.n32 VDD.n12 0.120292
R521 VDD.n34 VDD.n10 0.120292
R522 VDD.n39 VDD.n10 0.120292
R523 VDD.n41 VDD.n40 0.120292
R524 VDD.n41 VDD.n7 0.120292
R525 VDD.n7 VDD.n6 0.120292
R526 VDD.n46 VDD.n6 0.120292
R527 VDD.n48 VDD.n4 0.120292
R528 VDD.n53 VDD.n4 0.120292
R529 VDD.n55 VDD.n54 0.120292
R530 VDD.n55 VDD.n1 0.120292
R531 VDD.n1 VDD.n0 0.120292
R532 VDD.n208 VDD.n203 0.120292
R533 VDD.n209 VDD.n208 0.120292
R534 VDD.n210 VDD.n200 0.120292
R535 VDD.n214 VDD.n200 0.120292
R536 VDD.n215 VDD.n214 0.120292
R537 VDD.n216 VDD.n215 0.120292
R538 VDD.n222 VDD.n198 0.120292
R539 VDD.n223 VDD.n222 0.120292
R540 VDD.n224 VDD.n223 0.120292
R541 VDD.n224 VDD.n196 0.120292
R542 VDD.n228 VDD.n196 0.120292
R543 VDD.n229 VDD.n228 0.120292
R544 VDD.n230 VDD.n229 0.120292
R545 VDD.n125 VDD.n124 0.0734167
R546 VDD.n233 VDD.n193 0.0734167
R547 VDD VDD.n145 0.0603958
R548 VDD.n164 VDD 0.0603958
R549 VDD.n165 VDD 0.0603958
R550 VDD.n171 VDD 0.0603958
R551 VDD.n178 VDD 0.0603958
R552 VDD.n179 VDD 0.0603958
R553 VDD.n185 VDD 0.0603958
R554 VDD.n191 VDD.n127 0.0603958
R555 VDD.n191 VDD.n190 0.0603958
R556 VDD VDD.n80 0.0603958
R557 VDD VDD.n72 0.0603958
R558 VDD.n103 VDD 0.0603958
R559 VDD VDD.n67 0.0603958
R560 VDD.n20 VDD 0.0603958
R561 VDD.n26 VDD 0.0603958
R562 VDD.n33 VDD 0.0603958
R563 VDD.n34 VDD 0.0603958
R564 VDD.n40 VDD 0.0603958
R565 VDD.n47 VDD 0.0603958
R566 VDD.n48 VDD 0.0603958
R567 VDD.n54 VDD 0.0603958
R568 VDD.n60 VDD.n0 0.0603958
R569 VDD.n60 VDD.n59 0.0603958
R570 VDD VDD.n203 0.0603958
R571 VDD.n210 VDD 0.0603958
R572 VDD VDD.n198 0.0603958
R573 VDD.n125 VDD.n61 0.047375
R574 VDD.n230 VDD.n193 0.047375
R575 VDD VDD.n164 0.03175
R576 VDD VDD.n178 0.03175
R577 VDD.n96 VDD 0.03175
R578 VDD VDD.n33 0.03175
R579 VDD VDD.n47 0.03175
R580 VDD VDD.n170 0.0226354
R581 VDD VDD.n177 0.0226354
R582 VDD VDD.n184 0.0226354
R583 VDD.n190 VDD 0.0226354
R584 VDD VDD.n102 0.0226354
R585 VDD.n109 VDD 0.0226354
R586 VDD VDD.n25 0.0226354
R587 VDD VDD.n32 0.0226354
R588 VDD VDD.n39 0.0226354
R589 VDD VDD.n46 0.0226354
R590 VDD VDD.n53 0.0226354
R591 VDD.n59 VDD 0.0226354
R592 VDD VDD.n209 0.0226354
R593 VDD.n216 VDD 0.0226354
R594 VDD VDD.n163 0.0213333
R595 VDD VDD.n95 0.0213333
R596 VDD.n124 VDD 0.0213333
R597 VDD VDD.n233 0.0213333
R598 GND.n164 GND.n3 1.14107e+06
R599 GND.n165 GND.n164 25610.1
R600 GND.n255 GND 16585.9
R601 GND.n256 GND.n255 14208.7
R602 GND.n256 GND.n3 8731.2
R603 GND.n165 GND.n54 7517.94
R604 GND.t84 GND.n254 2662.78
R605 GND.t27 GND 2634.3
R606 GND.n164 GND.n163 2599.42
R607 GND.n2 GND 2458.82
R608 GND GND.n256 2447.12
R609 GND.t25 GND 2406.47
R610 GND.t64 GND.t25 2392.23
R611 GND.n31 GND.t18 2371.18
R612 GND.n27 GND.t88 2371.18
R613 GND.n163 GND.t33 2371.18
R614 GND.t4 GND.n67 2371.18
R615 GND.n68 GND.t68 2371.18
R616 GND GND.t20 2345.82
R617 GND GND.t57 2345.82
R618 GND.t35 GND 2345.82
R619 GND.t40 GND 2345.82
R620 GND GND.t37 2345.82
R621 GND.n257 GND.t78 2254.25
R622 GND.n166 GND.t76 2242.19
R623 GND GND.t55 2230.14
R624 GND GND.t42 2037.26
R625 GND.t42 GND.t7 2025.21
R626 GND.t76 GND.t51 2025.21
R627 GND GND.n3 1889.34
R628 GND.t39 GND.t6 1779.94
R629 GND.t0 GND.t23 1552.1
R630 GND GND.t84 1509.39
R631 GND.t61 GND.t9 1506.85
R632 GND.t10 GND.t13 1506.85
R633 GND.n255 GND 1496.25
R634 GND.t82 GND.t27 1381.23
R635 GND.t6 GND.t64 1366.99
R636 GND.t23 GND.t39 1366.99
R637 GND.t18 GND 1344.09
R638 GND.t88 GND 1344.09
R639 GND GND.t33 1344.09
R640 GND GND.t4 1344.09
R641 GND.t68 GND 1344.09
R642 GND GND.t94 1338.51
R643 GND.t44 GND.t49 1313.97
R644 GND.t78 GND 1277.81
R645 GND.t20 GND.t16 1229.97
R646 GND.t57 GND.t90 1229.97
R647 GND.t31 GND.t35 1229.97
R648 GND.t2 GND.t40 1229.97
R649 GND.t37 GND.t66 1229.97
R650 GND.n67 GND.n61 1198.25
R651 GND.n163 GND.n162 1198.25
R652 GND.n167 GND.n166 1198.25
R653 GND.n54 GND.n53 1198.25
R654 GND.n211 GND.n27 1198.25
R655 GND.n254 GND.n253 1198.25
R656 GND.n32 GND.n31 1198.25
R657 GND.n258 GND.n257 1198.25
R658 GND.n131 GND.n68 1198.25
R659 GND.n254 GND.n4 1196.12
R660 GND.t94 GND.t82 1196.12
R661 GND.t59 GND 1191.93
R662 GND.t86 GND 1191.93
R663 GND GND.t47 1191.93
R664 GND GND.t53 1191.93
R665 GND.t62 GND 1191.93
R666 GND.t55 GND.t80 1169.32
R667 GND.t7 GND.t61 1157.26
R668 GND.t9 GND.t44 1157.26
R669 GND.t51 GND.t10 1157.26
R670 GND.t13 GND.t70 1157.26
R671 GND.t92 GND 1133.15
R672 GND.t16 GND.t59 1065.13
R673 GND.t90 GND.t86 1065.13
R674 GND.t47 GND.t31 1065.13
R675 GND.t53 GND.t2 1065.13
R676 GND.t66 GND.t62 1065.13
R677 GND.t70 GND.n2 1048.77
R678 GND.n31 GND.n4 1039.77
R679 GND.n257 GND.n2 1012.6
R680 GND.t80 GND.t92 1012.6
R681 GND GND.n27 951.01
R682 GND.n67 GND 951.01
R683 GND.n68 GND 951.01
R684 GND.n2 GND.t11 880
R685 GND.n54 GND.t74 837.667
R686 GND.t74 GND.t29 756.602
R687 GND.t46 GND.t22 562.948
R688 GND.t72 GND.t14 490.89
R689 GND.n166 GND.n165 458.082
R690 GND.t29 GND.t46 432.344
R691 GND.t22 GND.t72 432.344
R692 GND.n2 GND 385.753
R693 GND.n93 GND.t93 246.506
R694 GND.n150 GND.t48 246.506
R695 GND.n66 GND.t54 246.506
R696 GND.n206 GND.t60 246.506
R697 GND.n219 GND.t87 246.506
R698 GND.n241 GND.t95 246.506
R699 GND.n119 GND.t63 246.506
R700 GND GND.n4 216.173
R701 GND.n79 GND.n78 210.601
R702 GND.n60 GND.n59 210.601
R703 GND.n137 GND.n65 210.601
R704 GND.n204 GND.n203 210.601
R705 GND.n224 GND.n217 210.601
R706 GND.n10 GND.n9 210.601
R707 GND.n117 GND.n116 210.601
R708 GND.n106 GND.n105 199.739
R709 GND.n182 GND.n181 199.739
R710 GND.n190 GND.n34 199.739
R711 GND.n18 GND.n16 199.739
R712 GND.n103 GND.n102 185
R713 GND.n101 GND.n100 185
R714 GND.n174 GND.n173 185
R715 GND.n172 GND.n171 185
R716 GND.n47 GND.n46 185
R717 GND.n49 GND.n48 185
R718 GND.n233 GND.n232 185
R719 GND.n235 GND.n234 185
R720 GND.n81 GND.t79 158.361
R721 GND.n158 GND.t34 158.361
R722 GND.n143 GND.t5 158.361
R723 GND.n197 GND.t19 158.361
R724 GND.n24 GND.t89 158.361
R725 GND.n6 GND.t85 158.361
R726 GND.n71 GND.t69 158.361
R727 GND GND.t0 142.395
R728 GND.t49 GND 120.549
R729 GND.n102 GND.n101 97.1434
R730 GND.n173 GND.n172 97.1434
R731 GND.n48 GND.n47 97.1434
R732 GND.n234 GND.n233 97.1434
R733 GND.n105 GND.t45 74.2862
R734 GND.n181 GND.t71 74.2862
R735 GND.n34 GND.t73 74.2862
R736 GND.n16 GND.t24 74.2862
R737 GND.n102 GND.t8 61.4291
R738 GND.n173 GND.t52 61.4291
R739 GND.n47 GND.t30 61.4291
R740 GND.n233 GND.t65 61.4291
R741 GND.n78 GND.t81 55.7148
R742 GND.n59 GND.t32 55.7148
R743 GND.n65 GND.t3 55.7148
R744 GND.n203 GND.t17 55.7148
R745 GND.n217 GND.t91 55.7148
R746 GND.n9 GND.t83 55.7148
R747 GND.n116 GND.t67 55.7148
R748 GND.t14 GND 45.0363
R749 GND.n101 GND.t43 38.5719
R750 GND.n172 GND.t77 38.5719
R751 GND.n48 GND.t75 38.5719
R752 GND.n234 GND.t26 38.5719
R753 GND.n83 GND.n1 34.6358
R754 GND.n87 GND.n86 34.6358
R755 GND.n88 GND.n87 34.6358
R756 GND.n92 GND.n91 34.6358
R757 GND.n94 GND.n76 34.6358
R758 GND.n99 GND.n76 34.6358
R759 GND.n111 GND.n104 34.6358
R760 GND.n111 GND.n110 34.6358
R761 GND.n110 GND.n109 34.6358
R762 GND.n170 GND.n169 34.6358
R763 GND.n179 GND.n38 34.6358
R764 GND.n180 GND.n179 34.6358
R765 GND.n183 GND.n180 34.6358
R766 GND.n152 GND.n151 34.6358
R767 GND.n157 GND.n156 34.6358
R768 GND.n156 GND.n57 34.6358
R769 GND.n159 GND.n55 34.6358
R770 GND.n145 GND.n144 34.6358
R771 GND.n142 GND.n63 34.6358
R772 GND.n138 GND.n63 34.6358
R773 GND.n136 GND.n135 34.6358
R774 GND.n45 GND.n43 34.6358
R775 GND.n43 GND.n35 34.6358
R776 GND.n189 GND.n35 34.6358
R777 GND.n50 GND.n40 34.6358
R778 GND.n196 GND.n195 34.6358
R779 GND.n198 GND.n29 34.6358
R780 GND.n202 GND.n29 34.6358
R781 GND.n207 GND.n205 34.6358
R782 GND.n213 GND.n212 34.6358
R783 GND.n226 GND.n216 34.6358
R784 GND.n226 GND.n225 34.6358
R785 GND.n223 GND.n218 34.6358
R786 GND.n252 GND.n5 34.6358
R787 GND.n248 GND.n247 34.6358
R788 GND.n247 GND.n7 34.6358
R789 GND.n243 GND.n242 34.6358
R790 GND.n240 GND.n11 34.6358
R791 GND.n236 GND.n11 34.6358
R792 GND.n231 GND.n14 34.6358
R793 GND.n20 GND.n14 34.6358
R794 GND.n20 GND.n19 34.6358
R795 GND.n130 GND.n70 34.6358
R796 GND.n126 GND.n125 34.6358
R797 GND.n125 GND.n72 34.6358
R798 GND.n121 GND.n120 34.6358
R799 GND.n78 GND.t56 26.8576
R800 GND.n59 GND.t36 26.8576
R801 GND.n65 GND.t41 26.8576
R802 GND.n203 GND.t21 26.8576
R803 GND.n217 GND.t58 26.8576
R804 GND.n9 GND.t28 26.8576
R805 GND.n116 GND.t38 26.8576
R806 GND.n105 GND.t50 25.4291
R807 GND.n181 GND.t12 25.4291
R808 GND.n34 GND.t15 25.4291
R809 GND.n16 GND.t1 25.4291
R810 GND.n258 GND.n1 23.7181
R811 GND.n169 GND.n167 23.7181
R812 GND.n149 GND.n61 23.7181
R813 GND.n162 GND.n55 23.7181
R814 GND.n145 GND.n61 23.7181
R815 GND.n132 GND.n131 23.7181
R816 GND.n191 GND.n32 23.7181
R817 GND.n53 GND.n40 23.7181
R818 GND.n195 GND.n32 23.7181
R819 GND.n211 GND.n26 23.7181
R820 GND.n212 GND.n211 23.7181
R821 GND.n253 GND.n252 23.7181
R822 GND.n131 GND.n130 23.7181
R823 GND.n109 GND.n106 22.9652
R824 GND.n183 GND.n182 22.9652
R825 GND.n190 GND.n189 22.9652
R826 GND.n19 GND.n18 22.9652
R827 GND.n104 GND.n103 22.2496
R828 GND.n174 GND.n38 22.2496
R829 GND.n46 GND.n45 22.2496
R830 GND.n232 GND.n231 22.2496
R831 GND.n191 GND.n190 21.4593
R832 GND.n186 GND.n185 16.3202
R833 GND.n229 GND.n228 16.1899
R834 GND.n114 GND.n113 16.1899
R835 GND.n88 GND.n79 16.1887
R836 GND.n60 GND.n57 16.1887
R837 GND.n138 GND.n137 16.1887
R838 GND.n204 GND.n202 16.1887
R839 GND.n225 GND.n224 16.1887
R840 GND.n10 GND.n7 16.1887
R841 GND.n117 GND.n72 16.1887
R842 GND.n93 GND.n92 15.0593
R843 GND.n151 GND.n150 15.0593
R844 GND.n135 GND.n66 15.0593
R845 GND.n207 GND.n206 15.0593
R846 GND.n219 GND.n218 15.0593
R847 GND.n242 GND.n241 15.0593
R848 GND.n120 GND.n119 15.0593
R849 GND.n100 GND.n99 11.7085
R850 GND.n171 GND.n170 11.7085
R851 GND.n50 GND.n49 11.7085
R852 GND.n236 GND.n235 11.7085
R853 GND.n220 GND.n219 10.8064
R854 GND.n119 GND.n118 10.8064
R855 GND.n83 GND.n81 10.5417
R856 GND.n159 GND.n158 10.5417
R857 GND.n144 GND.n143 10.5417
R858 GND.n197 GND.n196 10.5417
R859 GND.n213 GND.n24 10.5417
R860 GND.n6 GND.n5 10.5417
R861 GND.n71 GND.n70 10.5417
R862 GND.n253 GND 9.33305
R863 GND.n53 GND 9.33305
R864 GND.n162 GND 9.33305
R865 GND GND.n167 9.33305
R866 GND.n19 GND.n15 9.3005
R867 GND.n21 GND.n20 9.3005
R868 GND.n22 GND.n14 9.3005
R869 GND.n231 GND.n230 9.3005
R870 GND.n13 GND.n12 9.3005
R871 GND.n237 GND.n236 9.3005
R872 GND.n238 GND.n11 9.3005
R873 GND.n240 GND.n239 9.3005
R874 GND.n242 GND.n8 9.3005
R875 GND.n244 GND.n243 9.3005
R876 GND.n245 GND.n7 9.3005
R877 GND.n247 GND.n246 9.3005
R878 GND.n249 GND.n248 9.3005
R879 GND.n252 GND.n251 9.3005
R880 GND.n250 GND.n5 9.3005
R881 GND.n221 GND.n218 9.3005
R882 GND.n223 GND.n222 9.3005
R883 GND.n225 GND.n23 9.3005
R884 GND.n227 GND.n226 9.3005
R885 GND.n216 GND.n215 9.3005
R886 GND.n52 GND.n40 9.3005
R887 GND.n51 GND.n50 9.3005
R888 GND.n42 GND.n41 9.3005
R889 GND.n45 GND.n44 9.3005
R890 GND.n43 GND.n36 9.3005
R891 GND.n187 GND.n35 9.3005
R892 GND.n189 GND.n188 9.3005
R893 GND.n190 GND.n33 9.3005
R894 GND.n192 GND.n191 9.3005
R895 GND.n195 GND.n194 9.3005
R896 GND.n196 GND.n30 9.3005
R897 GND.n199 GND.n198 9.3005
R898 GND.n200 GND.n29 9.3005
R899 GND.n202 GND.n201 9.3005
R900 GND.n205 GND.n28 9.3005
R901 GND.n208 GND.n207 9.3005
R902 GND.n209 GND.n26 9.3005
R903 GND.n211 GND.n210 9.3005
R904 GND.n212 GND.n25 9.3005
R905 GND.n214 GND.n213 9.3005
R906 GND.n193 GND.n32 9.3005
R907 GND.n120 GND.n115 9.3005
R908 GND.n122 GND.n121 9.3005
R909 GND.n123 GND.n72 9.3005
R910 GND.n125 GND.n124 9.3005
R911 GND.n127 GND.n126 9.3005
R912 GND.n161 GND.n55 9.3005
R913 GND.n160 GND.n159 9.3005
R914 GND.n157 GND.n56 9.3005
R915 GND.n156 GND.n155 9.3005
R916 GND.n154 GND.n57 9.3005
R917 GND.n153 GND.n152 9.3005
R918 GND.n151 GND.n58 9.3005
R919 GND.n149 GND.n148 9.3005
R920 GND.n147 GND.n61 9.3005
R921 GND.n146 GND.n145 9.3005
R922 GND.n144 GND.n62 9.3005
R923 GND.n142 GND.n141 9.3005
R924 GND.n140 GND.n63 9.3005
R925 GND.n139 GND.n138 9.3005
R926 GND.n136 GND.n64 9.3005
R927 GND.n135 GND.n134 9.3005
R928 GND.n133 GND.n132 9.3005
R929 GND.n131 GND.n69 9.3005
R930 GND.n130 GND.n129 9.3005
R931 GND.n128 GND.n70 9.3005
R932 GND.n184 GND.n183 9.3005
R933 GND.n180 GND.n37 9.3005
R934 GND.n179 GND.n178 9.3005
R935 GND.n177 GND.n38 9.3005
R936 GND.n176 GND.n175 9.3005
R937 GND.n170 GND.n39 9.3005
R938 GND.n169 GND.n168 9.3005
R939 GND.n109 GND.n108 9.3005
R940 GND.n110 GND.n74 9.3005
R941 GND.n112 GND.n111 9.3005
R942 GND.n104 GND.n73 9.3005
R943 GND.n97 GND.n75 9.3005
R944 GND.n99 GND.n98 9.3005
R945 GND.n96 GND.n76 9.3005
R946 GND.n95 GND.n94 9.3005
R947 GND.n92 GND.n77 9.3005
R948 GND.n91 GND.n90 9.3005
R949 GND.n89 GND.n88 9.3005
R950 GND.n87 GND.n80 9.3005
R951 GND.n86 GND.n85 9.3005
R952 GND.n259 GND.n258 9.3005
R953 GND.n82 GND.n1 9.3005
R954 GND.n84 GND.n83 9.3005
R955 GND.n18 GND.n17 7.12063
R956 GND.n182 GND.n0 7.12063
R957 GND.n107 GND.n106 7.12063
R958 GND.n86 GND.n81 6.77697
R959 GND.n158 GND.n157 6.77697
R960 GND.n143 GND.n142 6.77697
R961 GND.n198 GND.n197 6.77697
R962 GND.n216 GND.n24 6.77697
R963 GND.n248 GND.n6 6.77697
R964 GND.n126 GND.n71 6.77697
R965 GND.n100 GND.n75 4.35795
R966 GND.n175 GND.n171 4.35795
R967 GND.n49 GND.n42 4.35795
R968 GND.n235 GND.n13 4.35795
R969 GND.n91 GND.n79 2.25932
R970 GND.n152 GND.n60 2.25932
R971 GND.n137 GND.n136 2.25932
R972 GND.n205 GND.n204 2.25932
R973 GND.n224 GND.n223 2.25932
R974 GND.n243 GND.n10 2.25932
R975 GND.n121 GND.n117 2.25932
R976 GND.n103 GND.n75 1.8161
R977 GND.n175 GND.n174 1.8161
R978 GND.n46 GND.n42 1.8161
R979 GND.n232 GND.n13 1.8161
R980 GND.n94 GND.n93 1.50638
R981 GND.n150 GND.n149 1.50638
R982 GND.n132 GND.n66 1.50638
R983 GND.n206 GND.n26 1.50638
R984 GND.n241 GND.n240 1.50638
R985 GND GND.n259 0.180188
R986 GND.n17 GND.n15 0.148519
R987 GND.n184 GND.n0 0.148519
R988 GND.n108 GND.n107 0.148519
R989 GND.n251 GND.n250 0.120292
R990 GND.n250 GND.n249 0.120292
R991 GND.n246 GND.n245 0.120292
R992 GND.n245 GND.n244 0.120292
R993 GND.n244 GND.n8 0.120292
R994 GND.n239 GND.n8 0.120292
R995 GND.n238 GND.n237 0.120292
R996 GND.n237 GND.n12 0.120292
R997 GND.n230 GND.n12 0.120292
R998 GND.n22 GND.n21 0.120292
R999 GND.n21 GND.n15 0.120292
R1000 GND.n52 GND.n51 0.120292
R1001 GND.n51 GND.n41 0.120292
R1002 GND.n44 GND.n41 0.120292
R1003 GND.n44 GND.n36 0.120292
R1004 GND.n188 GND.n187 0.120292
R1005 GND.n188 GND.n33 0.120292
R1006 GND.n192 GND.n33 0.120292
R1007 GND.n194 GND.n30 0.120292
R1008 GND.n199 GND.n30 0.120292
R1009 GND.n201 GND.n200 0.120292
R1010 GND.n201 GND.n28 0.120292
R1011 GND.n208 GND.n28 0.120292
R1012 GND.n209 GND.n208 0.120292
R1013 GND.n214 GND.n25 0.120292
R1014 GND.n215 GND.n214 0.120292
R1015 GND.n227 GND.n23 0.120292
R1016 GND.n222 GND.n23 0.120292
R1017 GND.n222 GND.n221 0.120292
R1018 GND.n221 GND.n220 0.120292
R1019 GND.n161 GND.n160 0.120292
R1020 GND.n160 GND.n56 0.120292
R1021 GND.n155 GND.n154 0.120292
R1022 GND.n154 GND.n153 0.120292
R1023 GND.n153 GND.n58 0.120292
R1024 GND.n148 GND.n58 0.120292
R1025 GND.n146 GND.n62 0.120292
R1026 GND.n141 GND.n62 0.120292
R1027 GND.n140 GND.n139 0.120292
R1028 GND.n139 GND.n64 0.120292
R1029 GND.n134 GND.n64 0.120292
R1030 GND.n134 GND.n133 0.120292
R1031 GND.n129 GND.n128 0.120292
R1032 GND.n128 GND.n127 0.120292
R1033 GND.n124 GND.n123 0.120292
R1034 GND.n123 GND.n122 0.120292
R1035 GND.n122 GND.n115 0.120292
R1036 GND.n118 GND.n115 0.120292
R1037 GND.n168 GND.n39 0.120292
R1038 GND.n176 GND.n39 0.120292
R1039 GND.n177 GND.n176 0.120292
R1040 GND.n178 GND.n177 0.120292
R1041 GND.n178 GND.n37 0.120292
R1042 GND.n84 GND.n82 0.120292
R1043 GND.n85 GND.n84 0.120292
R1044 GND.n89 GND.n80 0.120292
R1045 GND.n90 GND.n89 0.120292
R1046 GND.n90 GND.n77 0.120292
R1047 GND.n95 GND.n77 0.120292
R1048 GND.n98 GND.n96 0.120292
R1049 GND.n98 GND.n97 0.120292
R1050 GND.n97 GND.n73 0.120292
R1051 GND.n112 GND.n74 0.120292
R1052 GND.n108 GND.n74 0.120292
R1053 GND.n17 GND 0.11354
R1054 GND GND.n0 0.11354
R1055 GND.n107 GND 0.11354
R1056 GND.n230 GND.n229 0.0616979
R1057 GND.n113 GND.n73 0.0616979
R1058 GND.n251 GND 0.0603958
R1059 GND.n246 GND 0.0603958
R1060 GND GND.n238 0.0603958
R1061 GND GND.n52 0.0603958
R1062 GND.n186 GND.n36 0.0603958
R1063 GND.n187 GND.n186 0.0603958
R1064 GND.n193 GND 0.0603958
R1065 GND.n194 GND 0.0603958
R1066 GND.n200 GND 0.0603958
R1067 GND.n210 GND 0.0603958
R1068 GND GND.n25 0.0603958
R1069 GND GND.n161 0.0603958
R1070 GND.n155 GND 0.0603958
R1071 GND GND.n147 0.0603958
R1072 GND GND.n146 0.0603958
R1073 GND GND.n140 0.0603958
R1074 GND.n69 GND 0.0603958
R1075 GND.n129 GND 0.0603958
R1076 GND.n168 GND 0.0603958
R1077 GND.n185 GND.n37 0.0603958
R1078 GND.n185 GND.n184 0.0603958
R1079 GND.n82 GND 0.0603958
R1080 GND GND.n80 0.0603958
R1081 GND.n96 GND 0.0603958
R1082 GND.n229 GND.n22 0.0590938
R1083 GND.n113 GND.n112 0.0590938
R1084 GND.n228 GND.n227 0.0577917
R1085 GND.n124 GND.n114 0.0577917
R1086 GND GND.n193 0.0330521
R1087 GND.n210 GND 0.0330521
R1088 GND.n147 GND 0.0330521
R1089 GND GND.n69 0.0330521
R1090 GND.n259 GND 0.0330521
R1091 GND.n249 GND 0.0226354
R1092 GND.n239 GND 0.0226354
R1093 GND GND.n199 0.0226354
R1094 GND GND.n209 0.0226354
R1095 GND.n215 GND 0.0226354
R1096 GND.n220 GND 0.0226354
R1097 GND GND.n56 0.0226354
R1098 GND.n148 GND 0.0226354
R1099 GND.n141 GND 0.0226354
R1100 GND.n133 GND 0.0226354
R1101 GND.n127 GND 0.0226354
R1102 GND.n118 GND 0.0226354
R1103 GND.n85 GND 0.0226354
R1104 GND GND.n95 0.0226354
R1105 GND GND.n192 0.0213333
R1106 GND.n228 GND 0.00310417
R1107 GND.n114 GND 0.00310417
C0 P0 VDD 0.5821f
C1 x4.A VDD 0.64855f
C2 x4.A a_n910_n895# 0.2269f
C3 a_n2560_n1661# VDD 0.10304f
C4 P2 x5.A1 0.1179f
C5 x5.A0 x2.x4.A 0.13222f
C6 x1.x5.A0 VDD 0.5709f
C7 a_n2566_n895# A[6] 0.10296f
C8 A[1] x1.x5.A0 0.1118f
C9 P2 VDD 1.68197f
C10 a_n1738_n895# x4.A 0.11116f
C11 a_n1740_n1563# x2.x3.B 0.11079f
C12 a_n383_n1839# VDD 0.22365f
C13 x1.x4.A a_n1800_n2249# 0.23286f
C14 P1 x5.A1 0.10004f
C15 x1.x3.B a_n1800_n2249# 0.12167f
C16 x6.A1 x5.A1 0.24199f
C17 x2.x5.A0 A[7] 0.12736f
C18 x6.A0 x2.x3.B 0.18753f
C19 P1 VDD 0.58529f
C20 P2 P0 0.1537f
C21 x6.A1 VDD 1.18226f
C22 x4.A P2 0.14409f
C23 x2.x5.A1 a_n2131_n1839# 0.12552f
C24 x6.A1 A[1] 0.77519f
C25 a_n2628_n2249# A[2] 0.10296f
C26 VDD x2.x4.A 0.67588f
C27 x5.A1 x1.x4.A 0.13498f
C28 A[5] x2.x3.B 0.11669f
C29 x1.x3.B x5.A1 0.23358f
C30 a_n2628_n2249# x1.x4.A 0.10959f
C31 x2.x5.A1 A[5] 0.2058f
C32 A[5] x2.x5.A0 0.1118f
C33 x1.x5.A1 a_n2622_n3015# 0.1899f
C34 VDD x1.x4.A 0.68308f
C35 a_n2131_n1839# x5.A0 0.2206f
C36 x1.x3.B VDD 0.5044f
C37 x6.A0 x5.A0 0.20673f
C38 a_n383_n1839# P2 0.22735f
C39 x1.x3.B A[1] 0.11669f
C40 a_n1738_n895# x2.x4.A 0.23286f
C41 P1 P2 0.14732f
C42 x6.A1 P2 0.2867f
C43 x4.A x2.x4.A 0.26705f
C44 A[5] x5.A0 0.27538f
C45 x6.A1 a_n383_n1839# 0.10986f
C46 a_n1740_n1563# VDD 0.14784f
C47 x1.x5.A1 A[0] 0.17934f
C48 A[7] VDD 0.34588f
C49 x3.B x2.x3.B 0.14015f
C50 x2.x5.A1 x2.x5.A0 0.31199f
C51 a_n2131_n1839# VDD 0.16453f
C52 x6.A0 VDD 1.21886f
C53 a_n2566_n895# VDD 0.16289f
C54 a_n2628_n2249# A[3] 0.27166f
C55 A[3] VDD 0.3478f
C56 x5.A0 x2.x3.B 0.23468f
C57 a_n1802_n2917# A[0] 0.10682f
C58 A[5] VDD 0.24318f
C59 x2.x5.A1 x5.A0 0.48999f
C60 x2.x5.A0 x5.A0 0.10892f
C61 x1.x5.A1 x5.A1 0.46533f
C62 x3.B x5.A0 0.23794f
C63 x6.A1 x1.x3.B 0.20729f
C64 x6.A0 P0 0.21227f
C65 x3.B a_n1800_n2249# 0.11075f
C66 x1.x5.A1 VDD 0.26826f
C67 A[4] a_n1740_n1563# 0.10682f
C68 a_n2560_n1661# x6.A0 0.11064f
C69 x1.x5.A1 a_n2193_n3193# 0.12552f
C70 A[1] x1.x5.A1 0.20581f
C71 P2 x6.A0 0.13444f
C72 a_n2131_n1839# A[4] 0.12169f
C73 A[3] x1.x5.A0 0.12736f
C74 x1.x3.B x1.x4.A 0.31623f
C75 a_n964_n2347# x5.A1 0.22391f
C76 V VDD 0.26219f
C77 V a_n910_n895# 0.10962f
C78 a_n2622_n3015# x5.A1 0.31896f
C79 a_n1802_n2917# VDD 0.14345f
C80 a_n964_n2347# VDD 0.10343f
C81 A[5] A[4] 0.37239f
C82 x1.x5.A1 x1.x5.A0 0.31199f
C83 a_n1802_n2917# A[1] 0.26232f
C84 VDD x2.x3.B 0.52213f
C85 x2.x5.A1 VDD 0.32225f
C86 x2.x5.A0 VDD 0.66019f
C87 x3.B VDD 0.57566f
C88 x3.B a_n910_n895# 0.11716f
C89 x6.A1 x6.A0 0.3235f
C90 A[7] x2.x4.A 0.1499f
C91 V x4.A 0.12841f
C92 x5.A0 x5.A1 0.46968f
C93 a_n2566_n895# x2.x4.A 0.10959f
C94 a_n1738_n895# x2.x3.B 0.12167f
C95 a_n535_n2525# x5.A1 0.10512f
C96 V P2 0.11662f
C97 VDD a_n812_n1661# 0.10239f
C98 x5.A0 VDD 1.2611f
C99 x2.x5.A1 a_n2560_n1661# 0.1899f
C100 x3.B x4.A 0.18271f
C101 A[3] A[2] 0.18169f
C102 a_n535_n2525# VDD 0.21926f
C103 P2 a_n964_n2347# 0.32391f
C104 A[0] a_n2193_n3193# 0.12169f
C105 VDD a_n1800_n2249# 0.1786f
C106 A[1] A[0] 0.37804f
C107 A[3] x1.x4.A 0.14989f
C108 x2.x5.A1 A[4] 0.17934f
C109 P0 a_n812_n1661# 0.12068f
C110 a_n2560_n1661# x5.A0 0.31907f
C111 P1 a_n964_n2347# 0.13558f
C112 x6.A1 a_n2622_n3015# 0.11064f
C113 VDD x5.A1 1.07248f
C114 P2 a_n812_n1661# 0.33717f
C115 a_n2193_n3193# x5.A1 0.22021f
C116 P2 x5.A0 0.18513f
C117 a_n2628_n2249# VDD 0.16574f
C118 A[1] x5.A1 0.27142f
C119 a_n2566_n895# A[7] 0.2717f
C120 P2 a_n535_n2525# 0.21995f
C121 a_n910_n895# VDD 0.17857f
C122 a_n2193_n3193# VDD 0.15862f
C123 x2.x3.B x2.x4.A 0.31623f
C124 A[1] VDD 0.21162f
C125 A[5] a_n1740_n1563# 0.26232f
C126 a_n1802_n2917# x1.x3.B 0.11079f
C127 x6.A1 a_n812_n1661# 0.19788f
C128 A[6] A[7] 0.18245f
C129 A[5] x6.A0 0.7778f
C130 x1.x5.A0 x5.A1 0.10923f
C131 a_n1738_n895# VDD 0.17791f
C132 x3.B x1.x4.A 0.24624f
C133 A[0] GND 1.34934f
C134 A[1] GND 0.95478f
C135 P1 GND 0.82129f
C136 A[2] GND 0.41423f
C137 A[3] GND 0.61963f
C138 P0 GND 0.83058f
C139 A[4] GND 1.34638f
C140 A[5] GND 0.93495f
C141 P2 GND 2.19387f
C142 V GND 0.80356f
C143 A[6] GND 0.41449f
C144 A[7] GND 0.62971f
C145 VDD GND 20.30451f
C146 a_n2193_n3193# GND 0.26649f
C147 x1.x5.A1 GND 0.80102f
C148 a_n1802_n2917# GND 0.20111f
C149 a_n2622_n3015# GND 0.24744f
C150 a_n535_n2525# GND 0.31162f
C151 x5.A1 GND 1.10047f
C152 x1.x3.B GND 0.75034f
C153 x1.x5.A0 GND 0.84776f
C154 a_n964_n2347# GND 0.26635f
C155 x1.x4.A GND 0.7315f
C156 a_n1800_n2249# GND 0.20395f
C157 a_n2628_n2249# GND 0.21626f
C158 a_n383_n1839# GND 0.30571f
C159 x6.A1 GND 1.45204f
C160 a_n2131_n1839# GND 0.25888f
C161 x2.x5.A1 GND 0.60176f
C162 x6.A0 GND 0.46378f
C163 a_n812_n1661# GND 0.25504f
C164 a_n1740_n1563# GND 0.19748f
C165 a_n2560_n1661# GND 0.24087f
C166 x3.B GND 0.86108f
C167 x5.A0 GND 1.00862f
C168 x2.x3.B GND 0.61168f
C169 x2.x5.A0 GND 0.83053f
C170 x4.A GND 0.85126f
C171 a_n910_n895# GND 0.20418f
C172 x2.x4.A GND 0.78345f
C173 a_n1738_n895# GND 0.2033f
C174 a_n2566_n895# GND 0.21698f
C175 VDD.t37 GND 0.15157f
C176 VDD.t64 GND 0.15749f
C177 VDD.n17 GND 0.15716f
C178 VDD.t40 GND 0.15157f
C179 VDD.t2 GND 0.15749f
C180 VDD.n18 GND 0.15716f
C181 VDD.t35 GND 0.15157f
C182 VDD.t33 GND 0.21508f
C183 VDD.n19 GND 0.20672f
C184 VDD.t42 GND 0.11395f
C185 VDD.t58 GND 0.17039f
C186 VDD.t9 GND 0.15373f
C187 VDD.t44 GND 0.14244f
C188 VDD.t53 GND 0.15157f
C189 VDD.t76 GND 0.15749f
C190 VDD.n73 GND 0.23068f
C191 VDD.t70 GND 0.11395f
C192 VDD.t10 GND 0.17039f
C193 VDD.t13 GND 0.15373f
C194 VDD.t72 GND 0.20924f
C195 VDD.n81 GND 0.20611f
C196 VDD.n126 GND 0.27878f
C197 VDD.t55 GND 0.15157f
C198 VDD.t83 GND 0.15749f
C199 VDD.n146 GND 0.15716f
C200 VDD.t20 GND 0.15157f
C201 VDD.t16 GND 0.15749f
C202 VDD.n147 GND 0.18135f
C203 VDD.t66 GND 0.11395f
C204 VDD.t46 GND 0.17039f
C205 VDD.t22 GND 0.15373f
C206 VDD.t68 GND 0.20924f
C207 VDD.n148 GND 0.20611f
C208 VDD.n192 GND 0.29326f
C209 VDD.t25 GND 0.11395f
C210 VDD.t6 GND 0.17039f
C211 VDD.t39 GND 0.15373f
C212 VDD.t23 GND 0.14244f
C213 VDD.t27 GND 0.15157f
C214 VDD.t78 GND 0.21508f
C215 VDD.n204 GND 0.20672f
C216 A[7].n0 GND 0.11774f
C217 A[7].n4 GND 0.4575f
C218 A[6].n0 GND 0.10819f
C219 V.n0 GND 0.10415f
C220 V.n1 GND 0.12164f
C221 P2.n0 GND 0.11044f
C222 P2.t0 GND 0.15684f
C223 P2.t1 GND 0.10911f
C224 P2.n2 GND 0.18782f
C225 P2.n3 GND 0.527f
C226 P2.n4 GND 0.11044f
C227 P2.n5 GND 0.26426f
C228 P2.n7 GND 0.81336f
C229 P2.n8 GND 0.13295f
C230 P2.n9 GND 0.26426f
C231 A[5].t2 GND 0.10505f
C232 A[5].n0 GND 0.19716f
C233 A[5].n2 GND 0.13067f
C234 A[5].n4 GND 0.75264f
C235 A[5].n5 GND 0.55002f
C236 A[4].n0 GND 0.15631f
C237 A[4].n1 GND 0.11979f
C238 A[4].n2 GND 0.14958f
C239 P0.n0 GND 0.10953f
C240 P0.n3 GND 0.1239f
C241 A[3].n0 GND 0.11935f
C242 A[3].n4 GND 0.46375f
C243 A[2].n0 GND 0.1084f
C244 P1.n0 GND 0.10472f
C245 P1.n3 GND 0.12414f
C246 A[1].t2 GND 0.10225f
C247 A[1].n0 GND 0.19191f
C248 A[1].n2 GND 0.12719f
C249 A[1].n4 GND 0.73258f
C250 A[1].n5 GND 0.53536f
C251 A[0].n0 GND 0.14989f
C252 A[0].n1 GND 0.11488f
C253 A[0].n2 GND 0.14344f
.ends
