.include /usr/local/share/pdk/sky130A/libs.ref/sky130_fd_sc_hd/spice/sky130_fd_sc_hd.spice
.include /media/sf_VLSI/group-02-vlsi-16-bit-zlc-counter-main/frontend/xschem/lzc16.spice
